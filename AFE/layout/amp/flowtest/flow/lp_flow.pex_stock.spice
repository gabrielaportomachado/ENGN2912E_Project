* NGSPICE file created from lp_flow (flattened) - technology: gf180mcuD

.subckt lp_flow S1 D1 G1 S2 D2 G2 ND NS NG VSS DD GS GG BOTNET TOPNET
X0 D2 G2 S2 S2 pfet_03v3 ad=0.2166p pd=2.06u as=0.2166p ps=2.06u w=0.22u l=0.5u
X1 TOPNET BOTNET cap_mim_2f0_m4m5_noshield c_width=5u c_length=5u
X2 GS GG DD VSS nfet_03v3 ad=1.22p pd=5.22u as=1.22p ps=5.22u w=2u l=1u
X3 NS NG ND VSS nfet_06v0_nvt ad=5.7p pd=21.14u as=5.7p ps=21.14u w=10u l=2u
X4 D1 G1 S1 S1 pfet_03v3 ad=0.2166p pd=2.06u as=0.2166p ps=2.06u w=0.22u l=0.5u
C0 DD GS 0.04743f
C1 ND NS 0.18748f
C2 G2 S2 0.29971f
C3 D2 S2 0.09147f
C4 BOTNET TOPNET 0.33458f
C5 GG GS 0.02835f
C6 ND NG 0.28224f
C7 G1 S1 0.29971f
C8 NS NG 0.28224f
C9 GG DD 0.02835f
C10 D1 S1 0.09147f
C11 TOPNET VSS 0.76102f
C12 BOTNET VSS 1.0435f
C13 GS VSS 0.0975f
C14 DD VSS 0.10882f
C15 GG VSS 0.38584f
C16 NS VSS 0.39991f
C17 ND VSS 0.39967f
C18 NG VSS 0.78112f
C19 D2 VSS 0.01433f
C20 D1 VSS 0.01433f
C21 G2 VSS 0.15298f
C22 G1 VSS 0.15298f
C23 S2 VSS 0.94017f
C24 S1 VSS 0.94017f
.ends
