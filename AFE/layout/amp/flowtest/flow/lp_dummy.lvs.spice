* NGSPICE file created from lp_dummy.ext - technology: gf180mcuD

.subckt nfet__4 a_342_n60# a_238_0# a_542_0# a_38_n60# a_n84_0# VSUBS
X0 a_542_0# a_342_n60# a_238_0# VSUBS nfet_03v3 ad=1.22p pd=5.22u as=0.52p ps=2.52u w=2u l=1u
X1 a_238_0# a_38_n60# a_n84_0# VSUBS nfet_03v3 ad=0.52p pd=2.52u as=1.22p ps=5.22u w=2u l=1u
.ends

.subckt lp_dummy S D G VSS
Xnfet__4_0 G D S G S VSS nfet__4
.ends
