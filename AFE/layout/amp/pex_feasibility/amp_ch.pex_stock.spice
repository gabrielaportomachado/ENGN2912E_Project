* NGSPICE file created from amp_ch (flattened) - technology: gf180mcuD

.subckt amp_ch rec ref vbn vcm vg1 vcmo vg2 vrs out sw_rec sw_rec_b rst_amp
+ vdd vss
X0 a_3438_1504# vbn vss vss nfet_03v3 ad=4.16p pd=16.52u as=4.16p ps=16.52u w=16u l=4u
X1 w_24820_9696# vcm cap_mim_2f0_m4m5_noshield c_width=9.79u c_length=9.79u
X2 a_8438_27702# w_24820_9696# a_3108_27702# vdd pfet_03v3 ad=13p pd=50.52u as=13p ps=50.52u w=50u l=2u
X3 vss a_8438_27702# w_23620_9696# vss nfet_03v3 ad=30.5p pd=0.10122m as=13p ps=50.52u w=50u l=16u
X4 vss a_8438_27702# w_23620_9696# vss nfet_03v3 ad=13p pd=50.52u as=13p ps=50.52u w=50u l=16u
X5 a_22438_9664# a_23038_7140# vrs vss nfet_03v3 ad=0.305p pd=2.22u as=0.305p ps=2.22u w=0.5u l=0.5u
X6 a_22438_9664# a_23038_7140# vg1 vdd pfet_03v3 ad=0.325p pd=2.3u as=0.325p ps=2.3u w=0.5u l=0.5u
X7 a_10638_8600# vss cap_mim_2f0_m4m5_noshield c_width=31.465u c_length=31.465u
X8 a_20838_8600# vss cap_mim_2f0_m4m5_noshield c_width=44.595u c_length=44.595u
X9 a_10638_7200# vcmo a_2516_7200# vss nfet_03v3 ad=0.305p pd=2.22u as=0.305p ps=2.22u w=0.5u l=40u
X10 vss vbn a_3438_1504# vss nfet_03v3 ad=4.16p pd=16.52u as=4.16p ps=16.52u w=16u l=4u
X11 a_8438_27702# a_3038_14444# vss vss nfet_03v3 ad=30.5p pd=0.10122m as=30.5p ps=0.10122m w=50u l=16u
X12 a_3108_27702# a_3438_1504# vdd vdd pfet_03v3 ad=13p pd=50.52u as=32.5p ps=0.1013m w=50u l=4u
X13 a_8438_27702# w_24820_9696# a_3108_27702# vdd pfet_03v3 ad=13p pd=50.52u as=13p ps=50.52u w=50u l=2u
X14 w_22220_9696# w_23620_9696# cap_mim_2f0_m4m5_noshield c_width=9.79u c_length=9.79u
X15 a_27116_7200# a_20838_8600# vss vss nfet_03v3 ad=0.61p pd=3.22u as=0.61p ps=3.22u w=1u l=0.5u
X16 a_23038_7140# a_31867_10603# vdd vdd pfet_05v0 ad=0.5368p pd=3.32u as=0.38705p ps=2.08u w=1.22u l=0.5u
X17 vss vbn a_3438_1504# vss nfet_03v3 ad=4.16p pd=16.52u as=4.16p ps=16.52u w=16u l=4u
X18 vdd a_3438_1504# w_23620_9696# vdd pfet_03v3 ad=32.5p pd=0.1013m as=13p ps=50.52u w=50u l=4u
X19 a_3438_1504# vbn vss vss nfet_03v3 ad=4.16p pd=16.52u as=4.16p ps=16.52u w=16u l=4u
X20 a_3038_14444# w_22220_9696# a_3108_27702# vdd pfet_03v3 ad=13p pd=50.52u as=32.5p ps=0.1013m w=50u l=2u
X21 a_3038_14444# w_22220_9696# a_3108_27702# vdd pfet_03v3 ad=13p pd=50.52u as=13p ps=50.52u w=50u l=2u
X22 a_27338_7200# sw_rec a_27116_7200# vss nfet_03v3 ad=0.61p pd=3.22u as=0.61p ps=3.22u w=1u l=0.5u
X23 a_3108_27702# w_22220_9696# a_3038_14444# vdd pfet_03v3 ad=32.5p pd=0.1013m as=13p ps=50.52u w=50u l=2u
X24 a_3038_14444# w_22220_9696# a_3108_27702# vdd pfet_03v3 ad=13p pd=50.52u as=13p ps=50.52u w=50u l=2u
X25 a_3108_27702# w_22220_9696# a_3038_14444# vdd pfet_03v3 ad=13p pd=50.52u as=13p ps=50.52u w=50u l=2u
X26 a_10638_7200# a_10638_7200# vdd vdd pfet_03v3 ad=0.65p pd=3.3u as=0.65p ps=3.3u w=1u l=20u
X27 a_22538_9800# a_22438_9664# w_23620_9696# w_23620_9696# pfet_03v3 ad=0.2166p pd=2.06u as=0.2166p ps=2.06u w=0.22u l=0.5u
X28 a_20838_8600# sw_rec vdd vdd pfet_03v3 ad=0.65p pd=3.3u as=0.65p ps=3.3u w=1u l=0.5u
X29 a_2516_7200# vbn vss vss nfet_03v3 ad=0.61p pd=3.22u as=0.61p ps=3.22u w=1u l=20u
X30 a_3438_1504# vbn vss vss nfet_03v3 ad=4.16p pd=16.52u as=4.16p ps=16.52u w=16u l=4u
X31 vss vbn a_3438_1504# vss nfet_03v3 ad=4.16p pd=16.52u as=4.16p ps=16.52u w=16u l=4u
X32 a_8438_27702# w_24820_9696# a_3108_27702# vdd pfet_03v3 ad=13p pd=50.52u as=32.5p ps=0.1013m w=50u l=2u
X33 w_27420_9696# out cap_mim_2f0_m4m5_noshield c_width=11.92u c_length=11.92u
X34 a_3438_1504# vbn vss vss nfet_03v3 ad=4.16p pd=16.52u as=4.16p ps=16.52u w=16u l=4u
X35 a_22538_9800# a_22438_9664# w_22220_9696# w_22220_9696# pfet_03v3 ad=0.2166p pd=2.06u as=0.2166p ps=2.06u w=0.22u l=0.5u
X36 rec sw_rec vcm vdd pfet_03v3 ad=1.3p pd=5.3u as=1.3p ps=5.3u w=2u l=0.5u
X37 a_3108_27702# w_22220_9696# a_3038_14444# vdd pfet_03v3 ad=13p pd=50.52u as=13p ps=50.52u w=50u l=2u
X38 a_30138_7200# a_27338_7200# vss vss nfet_03v3 ad=0.61p pd=3.22u as=0.61p ps=3.22u w=1u l=0.5u
X39 a_3038_14444# a_3038_14444# vss vss nfet_03v3 ad=30.5p pd=0.10122m as=30.5p ps=0.10122m w=50u l=16u
X40 vss vbn out vss nfet_03v3 ad=4.16p pd=16.52u as=4.16p ps=16.52u w=16u l=4u
X41 a_27738_9800# a_24538_7200# w_27420_9696# w_27420_9696# pfet_03v3 ad=0.2166p pd=2.06u as=0.2166p ps=2.06u w=0.22u l=0.5u
X42 a_8438_27702# w_24820_9696# a_3108_27702# vdd pfet_03v3 ad=13p pd=50.52u as=32.5p ps=0.1013m w=50u l=2u
X43 a_8438_27702# w_24820_9696# a_3108_27702# vdd pfet_03v3 ad=13p pd=50.52u as=13p ps=50.52u w=50u l=2u
X44 a_24538_7200# a_23038_7140# vg2 vdd pfet_03v3 ad=0.325p pd=2.3u as=0.325p ps=2.3u w=0.5u l=0.5u
X45 vdd a_10638_8600# out vss nfet_06v0_nvt ad=5.7p pd=21.14u as=5.7p ps=21.14u w=10u l=2u
X46 vss vbn a_3438_1504# vss nfet_03v3 ad=4.16p pd=16.52u as=4.16p ps=16.52u w=16u l=4u
X47 a_3108_27702# w_24820_9696# a_8438_27702# vdd pfet_03v3 ad=13p pd=50.52u as=13p ps=50.52u w=50u l=2u
X48 a_3108_27702# w_24820_9696# a_8438_27702# vdd pfet_03v3 ad=13p pd=50.52u as=13p ps=50.52u w=50u l=2u
X49 a_10638_8600# w_27420_9696# a_2516_7200# vss nfet_03v3 ad=0.305p pd=2.22u as=0.305p ps=2.22u w=0.5u l=40u
X50 a_3438_1504# vbn vss vss nfet_03v3 ad=4.16p pd=16.52u as=4.16p ps=16.52u w=16u l=4u
X51 w_27420_9696# w_23620_9696# cap_mim_2f0_m4m5_noshield c_width=38.59u c_length=38.59u
X52 vdd rst_amp a_32055_10603# vdd pfet_05v0 ad=0.38705p pd=2.08u as=0.1469p ps=1.085u w=0.565u l=0.5u
X53 vss vbn a_3438_1504# vss nfet_03v3 ad=4.16p pd=16.52u as=4.16p ps=16.52u w=16u l=4u
X54 w_23620_9696# a_3438_1504# vdd vdd pfet_03v3 ad=13p pd=50.52u as=32.5p ps=0.1013m w=50u l=4u
X55 a_27338_7200# a_20838_8600# vdd vdd pfet_03v3 ad=0.65p pd=3.3u as=0.65p ps=3.3u w=1u l=0.5u
X56 a_31867_10603# a_30138_7200# vss vss nfet_05v0 ad=93.59999f pd=0.88u as=0.1584p ps=1.6u w=0.36u l=0.6u
X57 a_3108_27702# w_24820_9696# a_8438_27702# vdd pfet_03v3 ad=13p pd=50.52u as=13p ps=50.52u w=50u l=2u
X58 a_3438_1504# vbn vss vss nfet_03v3 ad=4.16p pd=16.52u as=9.76p ps=33.22u w=16u l=4u
X59 vdd a_3438_1504# a_3438_1504# vdd pfet_03v3 ad=32.5p pd=0.1013m as=13p ps=50.52u w=50u l=4u
X60 w_24820_9696# ref cap_mim_2f0_m4m5_noshield c_width=70.65u c_length=70.65u
X61 out vbn vss vss nfet_03v3 ad=4.16p pd=16.52u as=4.16p ps=16.52u w=16u l=4u
X62 a_8438_27702# w_24820_9696# a_3108_27702# vdd pfet_03v3 ad=13p pd=50.52u as=13p ps=50.52u w=50u l=2u
X63 vss rst_amp a_31867_10603# vss nfet_05v0 ad=0.2288p pd=1.58u as=93.59999f ps=0.88u w=0.36u l=0.6u
X64 a_3108_27702# w_24820_9696# a_8438_27702# vdd pfet_03v3 ad=13p pd=50.52u as=13p ps=50.52u w=50u l=2u
X65 w_22220_9696# rec cap_mim_2f0_m4m5_noshield c_width=70.65u c_length=70.65u
X66 a_3438_1504# vbn vss vss nfet_03v3 ad=4.16p pd=16.52u as=4.16p ps=16.52u w=16u l=4u
X67 a_27338_7200# sw_rec vdd vdd pfet_03v3 ad=0.65p pd=3.3u as=0.65p ps=3.3u w=1u l=0.5u
X68 vss vbn out vss nfet_03v3 ad=4.16p pd=16.52u as=4.16p ps=16.52u w=16u l=4u
X69 w_23620_9696# a_8438_27702# vss vss nfet_03v3 ad=13p pd=50.52u as=13p ps=50.52u w=50u l=16u
X70 a_3108_27702# w_22220_9696# a_3038_14444# vdd pfet_03v3 ad=13p pd=50.52u as=13p ps=50.52u w=50u l=2u
X71 a_3038_14444# w_22220_9696# a_3108_27702# vdd pfet_03v3 ad=13p pd=50.52u as=13p ps=50.52u w=50u l=2u
X72 a_3038_14444# w_22220_9696# a_3108_27702# vdd pfet_03v3 ad=13p pd=50.52u as=32.5p ps=0.1013m w=50u l=2u
X73 a_10638_8600# w_27420_9696# a_2516_7200# vss nfet_03v3 ad=0.305p pd=2.22u as=0.305p ps=2.22u w=0.5u l=40u
X74 a_3108_27702# w_22220_9696# a_3038_14444# vdd pfet_03v3 ad=32.5p pd=0.1013m as=13p ps=50.52u w=50u l=2u
X75 a_3438_1504# vbn vss vss nfet_03v3 ad=4.16p pd=16.52u as=4.16p ps=16.52u w=16u l=4u
X76 a_3038_14444# a_3038_14444# vss vss nfet_03v3 ad=30.5p pd=0.10122m as=30.5p ps=0.10122m w=50u l=16u
X77 a_8438_27702# w_24820_9696# a_3108_27702# vdd pfet_03v3 ad=13p pd=50.52u as=13p ps=50.52u w=50u l=2u
X78 a_30138_7200# a_27338_7200# vdd vdd pfet_03v3 ad=1.3p pd=5.3u as=1.3p ps=5.3u w=2u l=0.5u
X79 vss vbn a_3438_1504# vss nfet_03v3 ad=4.16p pd=16.52u as=4.16p ps=16.52u w=16u l=4u
X80 a_27738_9800# a_24538_7200# out out pfet_03v3 ad=0.2166p pd=2.06u as=0.2166p ps=2.06u w=0.22u l=0.5u
X81 a_3108_27702# w_22220_9696# a_3038_14444# vdd pfet_03v3 ad=13p pd=50.52u as=13p ps=50.52u w=50u l=2u
X82 out vbn vss vss nfet_03v3 ad=4.16p pd=16.52u as=4.16p ps=16.52u w=16u l=4u
X83 vss vbn a_3438_1504# vss nfet_03v3 ad=4.16p pd=16.52u as=4.16p ps=16.52u w=16u l=4u
X84 vss vbn out vss nfet_03v3 ad=9.76p pd=33.22u as=4.16p ps=16.52u w=16u l=4u
X85 vss vbn a_3438_1504# vss nfet_03v3 ad=4.16p pd=16.52u as=4.16p ps=16.52u w=16u l=4u
X86 a_8438_27702# w_24820_9696# a_3108_27702# vdd pfet_03v3 ad=13p pd=50.52u as=13p ps=50.52u w=50u l=2u
X87 a_23038_7140# a_31867_10603# vss vss nfet_05v0 ad=0.3608p pd=2.52u as=0.2288p ps=1.58u w=0.82u l=0.6u
X88 a_3108_27702# w_24820_9696# a_8438_27702# vdd pfet_03v3 ad=13p pd=50.52u as=13p ps=50.52u w=50u l=2u
X89 a_3108_27702# w_24820_9696# a_8438_27702# vdd pfet_03v3 ad=32.5p pd=0.1013m as=13p ps=50.52u w=50u l=2u
X90 a_3438_1504# vbn vss vss nfet_03v3 ad=4.16p pd=16.52u as=4.16p ps=16.52u w=16u l=4u
X91 vdd a_3438_1504# a_3108_27702# vdd pfet_03v3 ad=32.5p pd=0.1013m as=13p ps=50.52u w=50u l=4u
X92 a_8438_27702# w_23620_9696# cap_mim_2f0_m4m5_noshield c_width=22u c_length=22u
X93 a_3438_1504# vbn vss vss nfet_03v3 ad=4.16p pd=16.52u as=4.16p ps=16.52u w=16u l=4u
X94 vss vbn a_3438_1504# vss nfet_03v3 ad=9.76p pd=33.22u as=4.16p ps=16.52u w=16u l=4u
X95 a_3108_27702# w_24820_9696# a_8438_27702# vdd pfet_03v3 ad=13p pd=50.52u as=13p ps=50.52u w=50u l=2u
X96 vss vbn a_3438_1504# vss nfet_03v3 ad=4.16p pd=16.52u as=4.16p ps=16.52u w=16u l=4u
X97 a_3108_27702# w_24820_9696# a_8438_27702# vdd pfet_03v3 ad=32.5p pd=0.1013m as=13p ps=50.52u w=50u l=2u
X98 a_10638_7200# vcmo a_2516_7200# vss nfet_03v3 ad=0.305p pd=2.22u as=0.305p ps=2.22u w=0.5u l=40u
X99 w_22220_9696# rec cap_mim_2f0_m4m5_noshield c_width=70.65u c_length=70.65u
X100 w_23620_9696# a_8438_27702# vss vss nfet_03v3 ad=13p pd=50.52u as=30.5p ps=0.10122m w=50u l=16u
X101 a_3438_1504# a_3438_1504# vdd vdd pfet_03v3 ad=13p pd=50.52u as=32.5p ps=0.1013m w=50u l=4u
X102 w_24820_9696# ref cap_mim_2f0_m4m5_noshield c_width=70.65u c_length=70.65u
X103 vss vbn a_3438_1504# vss nfet_03v3 ad=4.16p pd=16.52u as=4.16p ps=16.52u w=16u l=4u
X104 a_3108_27702# w_22220_9696# a_3038_14444# vdd pfet_03v3 ad=13p pd=50.52u as=13p ps=50.52u w=50u l=2u
X105 vss vbn a_3438_1504# vss nfet_03v3 ad=4.16p pd=16.52u as=4.16p ps=16.52u w=16u l=4u
X106 a_3038_14444# w_22220_9696# a_3108_27702# vdd pfet_03v3 ad=13p pd=50.52u as=13p ps=50.52u w=50u l=2u
X107 a_8438_27702# a_3038_14444# vss vss nfet_03v3 ad=30.5p pd=0.10122m as=30.5p ps=0.10122m w=50u l=16u
X108 a_3108_27702# w_22220_9696# a_3038_14444# vdd pfet_03v3 ad=13p pd=50.52u as=13p ps=50.52u w=50u l=2u
X109 a_3038_14444# w_22220_9696# a_3108_27702# vdd pfet_03v3 ad=13p pd=50.52u as=13p ps=50.52u w=50u l=2u
X110 a_3438_1504# vbn vss vss nfet_03v3 ad=4.16p pd=16.52u as=4.16p ps=16.52u w=16u l=4u
X111 a_32055_10603# a_30138_7200# a_31867_10603# vdd pfet_05v0 ad=0.1469p pd=1.085u as=0.2486p ps=2.01u w=0.565u l=0.5u
X112 a_25138_9800# a_22438_9664# vcm vcm pfet_03v3 ad=0.2166p pd=2.06u as=0.2166p ps=2.06u w=0.22u l=0.5u
X113 rec sw_rec_b vcm vss nfet_03v3 ad=0.61p pd=3.22u as=0.61p ps=3.22u w=1u l=0.5u
X114 out vbn vss vss nfet_03v3 ad=4.16p pd=16.52u as=9.76p ps=33.22u w=16u l=4u
X115 a_20838_8600# vbn vss vss nfet_03v3 ad=0.2128p pd=1.98u as=0.2128p ps=1.98u w=0.28u l=40u
X116 a_3038_14444# w_22220_9696# a_3108_27702# vdd pfet_03v3 ad=13p pd=50.52u as=13p ps=50.52u w=50u l=2u
X117 a_3438_1504# vbn vss vss nfet_03v3 ad=4.16p pd=16.52u as=4.16p ps=16.52u w=16u l=4u
X118 a_25138_9800# a_22438_9664# w_24820_9696# w_24820_9696# pfet_03v3 ad=0.2166p pd=2.06u as=0.2166p ps=2.06u w=0.22u l=0.5u
X119 a_24538_7200# a_23038_7140# vrs vss nfet_03v3 ad=0.305p pd=2.22u as=0.305p ps=2.22u w=0.5u l=0.5u
X120 a_10638_8600# a_10638_7200# vdd vdd pfet_03v3 ad=0.65p pd=3.3u as=0.65p ps=3.3u w=1u l=20u
C0 a_10638_8600# w_23620_9696# 5.98399f
C1 vdd ref 1.93038f
C2 vrs vg1 0.06302f
C3 a_10638_8600# a_27338_7200# 0.09945f
C4 a_8438_27702# w_24820_9696# 31.95f
C5 w_27420_9696# vcmo 1.35493f
C6 vbn sw_rec_b 0.34958f
C7 a_10638_7200# a_10638_8600# 0.95945f
C8 a_10638_8600# a_23038_7140# 0.06626f
C9 vcm a_8438_27702# 2.60232f
C10 vrs w_22220_9696# 0.15559f
C11 a_8438_27702# a_3038_14444# 9.32354f
C12 vrs rec 0.57077f
C13 sw_rec_b w_24820_9696# 0.86019f
C14 sw_rec a_10638_8600# 0.52424f
C15 a_10638_8600# out 2.15163f
C16 vcm sw_rec_b 1.42704f
C17 sw_rec_b a_3038_14444# 0.28842f
C18 a_30932_27642# vdd 17.9961f
C19 a_3438_1504# a_21956_27642# 0.16305f
C20 a_31867_10603# rst_amp 0.52526f
C21 a_2516_7200# rst_amp 0.12938f
C22 a_31867_10603# w_23620_9696# 0.01767f
C23 vrs vbn 1.66801f
C24 vdd a_10638_8600# 2.74588f
C25 a_31867_10603# a_23038_7140# 0.19373f
C26 w_22220_9696# a_3438_1504# 0.02008f
C27 a_24538_7200# w_27420_9696# 0.28958f
C28 a_2516_7200# a_10638_7200# 0.18382f
C29 ref vcmo 0.68451f
C30 a_8438_27702# vg2 2.52092f
C31 vdd a_23248_27642# 17.6968f
C32 vrs w_24820_9696# 0.15287f
C33 a_25138_9800# a_10638_8600# 0.01615f
C34 a_3438_1504# rec 0.08185f
C35 a_22438_9664# w_27420_9696# 0.31614f
C36 w_22220_9696# vg1 0.06457f
C37 vrs vcm 11.9081f
C38 a_8438_27702# w_23620_9696# 13.6747f
C39 a_2516_7200# sw_rec 0.46505f
C40 sw_rec_b a_20838_8600# 0.06935f
C41 rec vg1 0.17053f
C42 a_22438_9664# a_24538_7200# 1.96922f
C43 sw_rec_b rst_amp 11.6306f
C44 a_8438_27702# a_19620_14444# 0.10832f
C45 sw_rec_b w_23620_9696# 2.37097f
C46 w_22220_9696# rec 13.4065f
C47 a_30138_7200# w_27420_9696# 0.3441f
C48 vbn a_3438_1504# 22.7079f
C49 w_27420_9696# ref 2.13838f
C50 vdd a_31867_10603# 0.48616f
C51 w_23620_9696# a_27738_9800# 0.01397f
C52 a_8438_27702# out 2.50349f
C53 a_3108_27702# a_23248_27642# 0.09312f
C54 sw_rec_b a_23038_7140# 0.0265f
C55 vbn vg1 0.03534f
C56 a_30138_7200# a_24538_7200# 0.32682f
C57 a_3438_1504# a_22538_9800# 0.09449f
C58 a_3438_1504# w_24820_9696# 5.17326f
C59 a_21956_27642# w_24820_9696# 0.10783f
C60 a_30138_7200# a_22438_9664# 0.1453f
C61 sw_rec_b sw_rec 0.17488f
C62 vcm a_3438_1504# 1.33796f
C63 w_22220_9696# vbn 0.06373f
C64 vrs vg2 0.09784f
C65 vg1 w_24820_9696# 1.0191f
C66 a_8438_27702# vdd 3.98048f
C67 a_3038_14444# a_21956_27642# 0.02475f
C68 vrs rst_amp 0.07441f
C69 sw_rec a_27738_9800# 0.01202f
C70 vbn rec 0.26937f
C71 out a_27738_9800# 0.24623f
C72 vcm vg1 0.29908f
C73 w_22220_9696# a_22538_9800# 0.12794f
C74 a_30932_27642# w_27420_9696# 0.33594f
C75 w_22220_9696# w_24820_9696# 11.4873f
C76 vcm w_22220_9696# 1.12147f
C77 vrs a_10638_7200# 0.16809f
C78 vrs a_23038_7140# 0.78812f
C79 w_22220_9696# a_3038_14444# 31.6694f
C80 sw_rec_b vdd 2.85978f
C81 rec w_24820_9696# 3.07133f
C82 a_10638_8600# w_27420_9696# 2.78502f
C83 vcm rec 1.38634f
C84 a_3038_14444# rec 1.62763f
C85 vrs sw_rec 23.75f
C86 a_25138_9800# sw_rec_b 0.06531f
C87 a_2516_7200# vcmo 2.31323f
C88 a_3438_1504# a_20838_8600# 0.07138f
C89 a_8438_27702# a_3108_27702# 17.0559f
C90 a_10638_8600# a_24538_7200# 0.53271f
C91 vbn w_24820_9696# 0.02917f
C92 a_3438_1504# rst_amp 0.08735f
C93 a_22438_9664# a_10638_8600# 0.07937f
C94 a_20838_8600# vg1 0.06459f
C95 vcm vbn 0.17305f
C96 a_3438_1504# w_23620_9696# 7.01079f
C97 vg1 vg2 2.55181f
C98 sw_rec_b a_3108_27702# 0.61337f
C99 a_21956_27642# w_23620_9696# 0.01007f
C100 vrs vdd 0.04827f
C101 vg1 rst_amp 0.10293f
C102 w_22220_9696# a_20838_8600# 0.05957f
C103 a_3438_1504# a_10638_7200# 1.30495f
C104 a_3438_1504# a_23038_7140# 0.11297f
C105 w_23620_9696# vg1 0.45934f
C106 vcm w_24820_9696# 2.45803f
C107 a_20838_8600# rec 0.19932f
C108 w_22220_9696# rst_amp 0.13773f
C109 a_3038_14444# w_24820_9696# 1.14444f
C110 a_30138_7200# a_10638_8600# 0.49576f
C111 a_2516_7200# w_27420_9696# 0.30925f
C112 rec vg2 0.24298f
C113 vg1 a_23038_7140# 1.67469f
C114 w_22220_9696# w_23620_9696# 1.42914f
C115 a_10638_8600# ref 1.09517f
C116 sw_rec_b vcmo 0.07433f
C117 a_3438_1504# sw_rec 0.0871f
C118 a_3438_1504# out 1.24852f
C119 rec rst_amp 0.11333f
C120 rec w_23620_9696# 0.08116f
C121 rec a_27338_7200# 0.69924f
C122 sw_rec vg1 0.0783f
C123 out vg1 0.09008f
C124 vbn a_20838_8600# 0.07347f
C125 a_8438_27702# w_27420_9696# 1.67701f
C126 rec a_23038_7140# 0.45658f
C127 w_22220_9696# a_2648_27642# 0.15966f
C128 w_22220_9696# sw_rec 0.84421f
C129 a_3438_1504# vdd 21.8963f
C130 vbn rst_amp 21.4597f
C131 a_22538_9800# a_20838_8600# 0.33479f
C132 vdd a_21956_27642# 16.3047f
C133 sw_rec rec 1.64268f
C134 rec out 0.08665f
C135 sw_rec_b w_27420_9696# 0.09025f
C136 vdd vg1 3.50214f
C137 vrs vcmo 7.02551f
C138 a_30138_7200# a_31867_10603# 0.58604f
C139 vcm a_20838_8600# 0.32578f
C140 vbn a_10638_7200# 5.77177f
C141 vcm vg2 0.11899f
C142 w_24820_9696# rst_amp 0.10873f
C143 w_27420_9696# a_27738_9800# 0.12804f
C144 a_22538_9800# w_23620_9696# 0.13091f
C145 w_23620_9696# w_24820_9696# 2.32385f
C146 w_22220_9696# vdd 11.3327f
C147 vcm rst_amp 0.09411f
C148 sw_rec_b a_24538_7200# 0.04823f
C149 a_27116_7200# rec 0.40545f
C150 vcm w_23620_9696# 0.42633f
C151 a_3038_14444# w_23620_9696# 2.23265f
C152 vbn sw_rec 0.71996f
C153 vcm a_27338_7200# 0.02784f
C154 vdd rec 2.03173f
C155 vbn out 4.79104f
C156 a_24538_7200# a_27738_9800# 1.34567f
C157 a_22438_9664# sw_rec_b 0.07815f
C158 a_3438_1504# a_3108_27702# 5.8928f
C159 vcm a_23038_7140# 0.67217f
C160 a_3108_27702# a_21956_27642# 1.49577f
C161 a_22438_9664# a_27738_9800# 0.07812f
C162 a_22538_9800# sw_rec 0.01315f
C163 sw_rec w_24820_9696# 0.84015f
C164 a_3038_14444# a_19620_14444# 1.47822f
C165 out w_24820_9696# 0.1345f
C166 vcm sw_rec 1.19981f
C167 vcm out 0.0879f
C168 a_3038_14444# a_2648_27642# 0.02381f
C169 vbn vdd 0.01831f
C170 w_22220_9696# a_3108_27702# 27.542f
C171 a_20838_8600# vg2 0.60942f
C172 sw_rec_b ref 0.14142f
C173 vrs a_24538_7200# 0.05145f
C174 a_3108_27702# rec 0.51798f
C175 vg1 vcmo 0.07295f
C176 a_2516_7200# a_10638_8600# 0.14255f
C177 a_20838_8600# w_23620_9696# 5.53535f
C178 vrs a_22438_9664# 0.3519f
C179 vcm a_27116_7200# 0.66199f
C180 w_23620_9696# vg2 0.57592f
C181 a_20838_8600# a_27338_7200# 2.12308f
C182 vdd w_24820_9696# 11.7215f
C183 vg2 a_27338_7200# 0.01666f
C184 vcm vdd 1.99297f
C185 w_22220_9696# vcmo 0.08096f
C186 a_20838_8600# a_23038_7140# 2.39147f
C187 w_23620_9696# rst_amp 0.12577f
C188 a_3038_14444# vdd 3.08552f
C189 vg2 a_23038_7140# 0.47823f
C190 a_25138_9800# w_24820_9696# 0.12794f
C191 rec vcmo 0.04633f
C192 a_10638_7200# rst_amp 0.16138f
C193 rst_amp a_23038_7140# 0.14032f
C194 a_3438_1504# w_27420_9696# 0.30609f
C195 vcm a_25138_9800# 0.20543f
C196 w_23620_9696# a_23038_7140# 0.09117f
C197 sw_rec a_20838_8600# 2.62014f
C198 a_20838_8600# out 0.16685f
C199 vrs ref 0.44961f
C200 sw_rec vg2 0.08601f
C201 a_27338_7200# a_23038_7140# 1.9453f
C202 out vg2 9.44327f
C203 w_27420_9696# vg1 5.10706f
C204 sw_rec rst_amp 0.07648f
C205 out rst_amp 0.09271f
C206 a_3108_27702# w_24820_9696# 28.3348f
C207 sw_rec_b a_10638_8600# 0.06673f
C208 out w_23620_9696# 2.07407f
C209 sw_rec a_27338_7200# 0.76687f
C210 vbn vcmo 23.1975f
C211 w_22220_9696# w_27420_9696# 0.53433f
C212 vcm a_3108_27702# 2.29616f
C213 a_27116_7200# a_20838_8600# 0.59354f
C214 out a_27338_7200# 0.0792f
C215 a_22438_9664# a_3438_1504# 0.49904f
C216 a_3108_27702# a_3038_14444# 17.0086f
C217 a_24538_7200# vg1 0.06829f
C218 a_10638_8600# a_27738_9800# 0.16508f
C219 a_2456_14444# a_3038_14444# 0.16385f
C220 a_10638_7200# sw_rec 0.10478f
C221 sw_rec a_23038_7140# 0.54289f
C222 a_20838_8600# vdd 3.64446f
C223 out a_23038_7140# 0.05362f
C224 a_10638_7200# out 0.9147f
C225 rec w_27420_9696# 0.10929f
C226 vdd vg2 4.60296f
C227 a_22438_9664# vg1 0.10644f
C228 vcmo w_24820_9696# 0.04315f
C229 a_27116_7200# a_27338_7200# 0.0976f
C230 vdd rst_amp 0.95591f
C231 sw_rec a_2648_27642# 0.13804f
C232 vdd w_23620_9696# 6.53186f
C233 vcm vcmo 11.8997f
C234 a_25138_9800# a_20838_8600# 0.2123f
C235 sw_rec out 0.09062f
C236 rec a_24538_7200# 0.5834f
C237 w_22220_9696# a_22438_9664# 0.3232f
C238 vdd a_27338_7200# 3.28758f
C239 a_27116_7200# a_23038_7140# 0.1038f
C240 vdd a_23038_7140# 1.6816f
C241 a_10638_7200# vdd 13.6973f
C242 a_22438_9664# rec 0.22395f
C243 vbn w_27420_9696# 0.24987f
C244 a_30138_7200# vg1 0.10801f
C245 a_25138_9800# w_23620_9696# 0.01845f
C246 ref vg1 0.51504f
C247 a_27116_7200# sw_rec 0.62595f
C248 a_27116_7200# out 0.19489f
C249 vdd a_2648_27642# 16.5295f
C250 sw_rec vdd 3.86981f
C251 vdd out 12.3359f
C252 w_22220_9696# ref 0.30141f
C253 w_27420_9696# w_24820_9696# 0.80989f
C254 vcm w_27420_9696# 0.37043f
C255 a_30138_7200# rec 0.10768f
C256 rec ref 7.36265f
C257 a_25138_9800# sw_rec 0.01402f
C258 a_8438_27702# sw_rec_b 2.23962f
C259 vcmo vg2 0.04044f
C260 vcm a_24538_7200# 0.37036f
C261 a_22438_9664# a_22538_9800# 1.48471f
C262 vcmo rst_amp 1.42313f
C263 a_22438_9664# w_24820_9696# 0.35213f
C264 a_3438_1504# a_10638_8600# 0.07356f
C265 vrs a_2516_7200# 4.42541f
C266 vcm a_22438_9664# 0.61444f
C267 a_3108_27702# a_2648_27642# 1.43412f
C268 sw_rec a_2456_14444# 0.17005f
C269 vbn ref 0.53201f
C270 a_10638_7200# vcmo 0.21798f
C271 a_3438_1504# a_23248_27642# 0.79568f
C272 a_10638_8600# vg1 0.05634f
C273 a_21956_27642# a_23248_27642# 0.12734f
C274 a_20838_8600# w_27420_9696# 1.43348f
C275 w_22220_9696# a_10638_8600# 0.12489f
C276 ref w_24820_9696# 16.0547f
C277 w_27420_9696# vg2 0.6798f
C278 vcm a_30138_7200# 1.61789f
C279 sw_rec vcmo 0.33826f
C280 vcm ref 0.76137f
C281 a_3108_27702# vdd 23.4895f
C282 w_27420_9696# rst_amp 2.25466f
C283 a_10638_8600# rec 0.96567f
C284 w_27420_9696# w_23620_9696# 3.75959f
C285 a_20838_8600# a_24538_7200# 0.56549f
C286 a_24538_7200# vg2 0.35952f
C287 vrs sw_rec_b 0.07403f
C288 a_22438_9664# a_20838_8600# 0.29898f
C289 a_10638_7200# w_27420_9696# 0.19142f
C290 a_22438_9664# vg2 0.21114f
C291 a_24538_7200# w_23620_9696# 0.08332f
C292 vdd vcmo 0.02435f
C293 a_24538_7200# a_27338_7200# 0.04274f
C294 a_31867_10603# vg1 0.02873f
C295 vbn a_10638_8600# 1.7261f
C296 a_22438_9664# w_23620_9696# 0.53905f
C297 a_24538_7200# a_23038_7140# 0.75011f
C298 sw_rec w_27420_9696# 0.28568f
C299 out w_27420_9696# 1.44318f
C300 a_22438_9664# a_27338_7200# 0.01695f
C301 a_30138_7200# a_20838_8600# 0.19179f
C302 a_8438_27702# a_3438_1504# 1.901f
C303 a_22438_9664# a_23038_7140# 1.18026f
C304 a_30138_7200# vg2 0.07791f
C305 a_20838_8600# ref 1.27373f
C306 ref vg2 0.75731f
C307 sw_rec a_24538_7200# 0.27322f
C308 out a_24538_7200# 0.39698f
C309 a_30138_7200# rst_amp 0.41587f
C310 vcm a_10638_8600# 0.75393f
C311 a_2516_7200# rec 0.0521f
C312 a_8438_27702# vg1 1.86394f
C313 ref rst_amp 0.15848f
C314 a_30138_7200# w_23620_9696# 0.26897f
C315 a_22438_9664# sw_rec 0.2137f
C316 a_23248_27642# w_24820_9696# 0.31729f
C317 a_30138_7200# a_27338_7200# 0.95011f
C318 w_23620_9696# ref 0.21555f
C319 vdd w_27420_9696# 3.40558f
C320 a_22438_9664# out 0.2013f
C321 a_3438_1504# sw_rec_b 1.45776f
C322 a_8438_27702# w_22220_9696# 0.09749f
C323 a_30138_7200# a_23038_7140# 0.1409f
C324 a_27116_7200# a_24538_7200# 0.02105f
C325 vdd a_24538_7200# 0.71237f
C326 a_8438_27702# rec 0.59982f
C327 vbn a_2516_7200# 2.64067f
C328 a_30138_7200# sw_rec 0.8531f
C329 a_30138_7200# out 0.07305f
C330 w_22220_9696# sw_rec_b 0.3184f
C331 a_22438_9664# vdd 0.40679f
C332 sw_rec ref 0.99385f
C333 out ref 0.99596f
C334 a_25138_9800# a_24538_7200# 0.14241f
C335 sw_rec_b rec 0.72276f
C336 a_20838_8600# a_10638_8600# 8.1507f
C337 a_30932_27642# w_23620_9696# 0.2111f
C338 a_10638_8600# vg2 0.37358f
C339 vrs a_3438_1504# 0.10663f
C340 a_25138_9800# a_22438_9664# 1.31739f
C341 a_30138_7200# vdd 3.29077f
C342 ref vss 28.4599f
C343 vg2 vss 22.5257f
C344 vg1 vss 23.5199f
C345 rec vss 25.4223f
C346 vrs vss 10.1585f
C347 sw_rec vss 19.8975f
C348 sw_rec_b vss 16.7217f
C349 vbn vss 91.96339f
C350 rst_amp vss 15.655f
C351 vcmo vss 26.4814f
C352 out vss 18.9313f
C353 vcm vss 21.3331f
C354 vdd vss 1.35471p
C355 a_27116_7200# vss 1.06416f
C356 a_27338_7200# vss 3.09219f
C357 a_27738_9800# vss 0.66303f
C358 a_24538_7200# vss 2.77495f
C359 a_25138_9800# vss 0.58117f
C360 a_20838_8600# vss 34.1987f
C361 a_22538_9800# vss 0.60875f
C362 a_22438_9664# vss 4.34099f
C363 a_23038_7140# vss 2.52933f
C364 a_31867_10603# vss 0.50616f
C365 a_30138_7200# vss 3.06323f
C366 a_10638_8600# vss 46.0177f
C367 a_10638_7200# vss 7.64441f
C368 a_2516_7200# vss 3.91945f
C369 a_19620_14444# vss 16.7792f $ **FLOATING
C370 a_2456_14444# vss 18.2612f $ **FLOATING
C371 a_30932_27642# vss 0.25879f $ **FLOATING
C372 a_23248_27642# vss 0.10012f $ **FLOATING
C373 a_21956_27642# vss 0.10012f $ **FLOATING
C374 a_8438_27702# vss 49.9072f
C375 a_3038_14444# vss 36.3621f
C376 a_3108_27702# vss 2.47562f
C377 a_3438_1504# vss 13.5084f
C378 a_2648_27642# vss 0.26226f $ **FLOATING
C379 w_27420_9696# vss 60.6755f
C380 w_24820_9696# vss 97.027f
C381 w_23620_9696# vss 28.7269f
C382 w_22220_9696# vss 96.4783f
.ends
