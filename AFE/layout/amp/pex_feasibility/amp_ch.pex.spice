* NGSPICE file created from amp_ch (flattened) - technology: gf180mcuD
* MIM correction of flow.py pex: capacitance to the layers below that Magic attached to MIM TOP plates was moved to the bottom plates:
*   a_10638_8600#: 8.94 fF -> vss; a_20838_8600#: 16.45 fF -> vss; a_8438_27702#: 3.76 fF -> w_23620_9696#; w_22220_9696#: 78.09 fF -> w_23620_9696# + rec; w_24820_9696#: 78.21 fF -> vcm + ref; w_27420_9696#: 13.80 fF -> out + w_23620_9696#
.subckt amp_ch rec ref vbn vcm vg1 vcmo vg2 vrs out sw_rec sw_rec_b rst_amp  vdd vss
X0 a_3438_1504# vbn vss vss nfet_03v3 ad=4.16p pd=16.52u as=4.16p ps=16.52u w=16u l=4u
X1 w_24820_9696# vcm cap_mim_2f0_m4m5_noshield c_width=9.79u c_length=9.79u
X2 a_8438_27702# w_24820_9696# a_3108_27702# vdd pfet_03v3 ad=13p pd=50.52u as=13p ps=50.52u w=50u l=2u
X3 vss a_8438_27702# w_23620_9696# vss nfet_03v3 ad=30.5p pd=0.10122m as=13p ps=50.52u w=50u l=16u
X4 vss a_8438_27702# w_23620_9696# vss nfet_03v3 ad=13p pd=50.52u as=13p ps=50.52u w=50u l=16u
X5 a_22438_9664# a_23038_7140# vrs vss nfet_03v3 ad=0.305p pd=2.22u as=0.305p ps=2.22u w=0.5u l=0.5u
X6 a_22438_9664# a_23038_7140# vg1 vdd pfet_03v3 ad=0.325p pd=2.3u as=0.325p ps=2.3u w=0.5u l=0.5u
X7 a_10638_8600# vss cap_mim_2f0_m4m5_noshield c_width=31.465u c_length=31.465u
X8 a_20838_8600# vss cap_mim_2f0_m4m5_noshield c_width=44.595u c_length=44.595u
X9 a_10638_7200# vcmo a_2516_7200# vss nfet_03v3 ad=0.305p pd=2.22u as=0.305p ps=2.22u w=0.5u l=40u
X10 vss vbn a_3438_1504# vss nfet_03v3 ad=4.16p pd=16.52u as=4.16p ps=16.52u w=16u l=4u
X11 a_8438_27702# a_3038_14444# vss vss nfet_03v3 ad=30.5p pd=0.10122m as=30.5p ps=0.10122m w=50u l=16u
X12 a_3108_27702# a_3438_1504# vdd vdd pfet_03v3 ad=13p pd=50.52u as=32.5p ps=0.1013m w=50u l=4u
X13 a_8438_27702# w_24820_9696# a_3108_27702# vdd pfet_03v3 ad=13p pd=50.52u as=13p ps=50.52u w=50u l=2u
X14 w_22220_9696# w_23620_9696# cap_mim_2f0_m4m5_noshield c_width=9.79u c_length=9.79u
X15 a_27116_7200# a_20838_8600# vss vss nfet_03v3 ad=0.61p pd=3.22u as=0.61p ps=3.22u w=1u l=0.5u
X16 a_23038_7140# a_31867_10603# vdd vdd pfet_05v0 ad=0.5368p pd=3.32u as=0.38705p ps=2.08u w=1.22u l=0.5u
X17 vss vbn a_3438_1504# vss nfet_03v3 ad=4.16p pd=16.52u as=4.16p ps=16.52u w=16u l=4u
X18 vdd a_3438_1504# w_23620_9696# vdd pfet_03v3 ad=32.5p pd=0.1013m as=13p ps=50.52u w=50u l=4u
X19 a_3438_1504# vbn vss vss nfet_03v3 ad=4.16p pd=16.52u as=4.16p ps=16.52u w=16u l=4u
X20 a_3038_14444# w_22220_9696# a_3108_27702# vdd pfet_03v3 ad=13p pd=50.52u as=32.5p ps=0.1013m w=50u l=2u
X21 a_3038_14444# w_22220_9696# a_3108_27702# vdd pfet_03v3 ad=13p pd=50.52u as=13p ps=50.52u w=50u l=2u
X22 a_27338_7200# sw_rec a_27116_7200# vss nfet_03v3 ad=0.61p pd=3.22u as=0.61p ps=3.22u w=1u l=0.5u
X23 a_3108_27702# w_22220_9696# a_3038_14444# vdd pfet_03v3 ad=32.5p pd=0.1013m as=13p ps=50.52u w=50u l=2u
X24 a_3038_14444# w_22220_9696# a_3108_27702# vdd pfet_03v3 ad=13p pd=50.52u as=13p ps=50.52u w=50u l=2u
X25 a_3108_27702# w_22220_9696# a_3038_14444# vdd pfet_03v3 ad=13p pd=50.52u as=13p ps=50.52u w=50u l=2u
X26 a_10638_7200# a_10638_7200# vdd vdd pfet_03v3 ad=0.65p pd=3.3u as=0.65p ps=3.3u w=1u l=20u
X27 a_22538_9800# a_22438_9664# w_23620_9696# w_23620_9696# pfet_03v3 ad=0.2166p pd=2.06u as=0.2166p ps=2.06u w=0.22u l=0.5u
X28 a_20838_8600# sw_rec vdd vdd pfet_03v3 ad=0.65p pd=3.3u as=0.65p ps=3.3u w=1u l=0.5u
X29 a_2516_7200# vbn vss vss nfet_03v3 ad=0.61p pd=3.22u as=0.61p ps=3.22u w=1u l=20u
X30 a_3438_1504# vbn vss vss nfet_03v3 ad=4.16p pd=16.52u as=4.16p ps=16.52u w=16u l=4u
X31 vss vbn a_3438_1504# vss nfet_03v3 ad=4.16p pd=16.52u as=4.16p ps=16.52u w=16u l=4u
X32 a_8438_27702# w_24820_9696# a_3108_27702# vdd pfet_03v3 ad=13p pd=50.52u as=32.5p ps=0.1013m w=50u l=2u
X33 w_27420_9696# out cap_mim_2f0_m4m5_noshield c_width=11.92u c_length=11.92u
X34 a_3438_1504# vbn vss vss nfet_03v3 ad=4.16p pd=16.52u as=4.16p ps=16.52u w=16u l=4u
X35 a_22538_9800# a_22438_9664# w_22220_9696# w_22220_9696# pfet_03v3 ad=0.2166p pd=2.06u as=0.2166p ps=2.06u w=0.22u l=0.5u
X36 rec sw_rec vcm vdd pfet_03v3 ad=1.3p pd=5.3u as=1.3p ps=5.3u w=2u l=0.5u
X37 a_3108_27702# w_22220_9696# a_3038_14444# vdd pfet_03v3 ad=13p pd=50.52u as=13p ps=50.52u w=50u l=2u
X38 a_30138_7200# a_27338_7200# vss vss nfet_03v3 ad=0.61p pd=3.22u as=0.61p ps=3.22u w=1u l=0.5u
X39 a_3038_14444# a_3038_14444# vss vss nfet_03v3 ad=30.5p pd=0.10122m as=30.5p ps=0.10122m w=50u l=16u
X40 vss vbn out vss nfet_03v3 ad=4.16p pd=16.52u as=4.16p ps=16.52u w=16u l=4u
X41 a_27738_9800# a_24538_7200# w_27420_9696# w_27420_9696# pfet_03v3 ad=0.2166p pd=2.06u as=0.2166p ps=2.06u w=0.22u l=0.5u
X42 a_8438_27702# w_24820_9696# a_3108_27702# vdd pfet_03v3 ad=13p pd=50.52u as=32.5p ps=0.1013m w=50u l=2u
X43 a_8438_27702# w_24820_9696# a_3108_27702# vdd pfet_03v3 ad=13p pd=50.52u as=13p ps=50.52u w=50u l=2u
X44 a_24538_7200# a_23038_7140# vg2 vdd pfet_03v3 ad=0.325p pd=2.3u as=0.325p ps=2.3u w=0.5u l=0.5u
X45 vdd a_10638_8600# out vss nfet_06v0_nvt ad=5.7p pd=21.14u as=5.7p ps=21.14u w=10u l=2u
X46 vss vbn a_3438_1504# vss nfet_03v3 ad=4.16p pd=16.52u as=4.16p ps=16.52u w=16u l=4u
X47 a_3108_27702# w_24820_9696# a_8438_27702# vdd pfet_03v3 ad=13p pd=50.52u as=13p ps=50.52u w=50u l=2u
X48 a_3108_27702# w_24820_9696# a_8438_27702# vdd pfet_03v3 ad=13p pd=50.52u as=13p ps=50.52u w=50u l=2u
X49 a_10638_8600# w_27420_9696# a_2516_7200# vss nfet_03v3 ad=0.305p pd=2.22u as=0.305p ps=2.22u w=0.5u l=40u
X50 a_3438_1504# vbn vss vss nfet_03v3 ad=4.16p pd=16.52u as=4.16p ps=16.52u w=16u l=4u
X51 w_27420_9696# w_23620_9696# cap_mim_2f0_m4m5_noshield c_width=38.59u c_length=38.59u
X52 vdd rst_amp a_32055_10603# vdd pfet_05v0 ad=0.38705p pd=2.08u as=0.1469p ps=1.085u w=0.565u l=0.5u
X53 vss vbn a_3438_1504# vss nfet_03v3 ad=4.16p pd=16.52u as=4.16p ps=16.52u w=16u l=4u
X54 w_23620_9696# a_3438_1504# vdd vdd pfet_03v3 ad=13p pd=50.52u as=32.5p ps=0.1013m w=50u l=4u
X55 a_27338_7200# a_20838_8600# vdd vdd pfet_03v3 ad=0.65p pd=3.3u as=0.65p ps=3.3u w=1u l=0.5u
X56 a_31867_10603# a_30138_7200# vss vss nfet_05v0 ad=93.59999f pd=0.88u as=0.1584p ps=1.6u w=0.36u l=0.6u
X57 a_3108_27702# w_24820_9696# a_8438_27702# vdd pfet_03v3 ad=13p pd=50.52u as=13p ps=50.52u w=50u l=2u
X58 a_3438_1504# vbn vss vss nfet_03v3 ad=4.16p pd=16.52u as=9.76p ps=33.22u w=16u l=4u
X59 vdd a_3438_1504# a_3438_1504# vdd pfet_03v3 ad=32.5p pd=0.1013m as=13p ps=50.52u w=50u l=4u
X60 w_24820_9696# ref cap_mim_2f0_m4m5_noshield c_width=70.65u c_length=70.65u
X61 out vbn vss vss nfet_03v3 ad=4.16p pd=16.52u as=4.16p ps=16.52u w=16u l=4u
X62 a_8438_27702# w_24820_9696# a_3108_27702# vdd pfet_03v3 ad=13p pd=50.52u as=13p ps=50.52u w=50u l=2u
X63 vss rst_amp a_31867_10603# vss nfet_05v0 ad=0.2288p pd=1.58u as=93.59999f ps=0.88u w=0.36u l=0.6u
X64 a_3108_27702# w_24820_9696# a_8438_27702# vdd pfet_03v3 ad=13p pd=50.52u as=13p ps=50.52u w=50u l=2u
X65 w_22220_9696# rec cap_mim_2f0_m4m5_noshield c_width=70.65u c_length=70.65u
X66 a_3438_1504# vbn vss vss nfet_03v3 ad=4.16p pd=16.52u as=4.16p ps=16.52u w=16u l=4u
X67 a_27338_7200# sw_rec vdd vdd pfet_03v3 ad=0.65p pd=3.3u as=0.65p ps=3.3u w=1u l=0.5u
X68 vss vbn out vss nfet_03v3 ad=4.16p pd=16.52u as=4.16p ps=16.52u w=16u l=4u
X69 w_23620_9696# a_8438_27702# vss vss nfet_03v3 ad=13p pd=50.52u as=13p ps=50.52u w=50u l=16u
X70 a_3108_27702# w_22220_9696# a_3038_14444# vdd pfet_03v3 ad=13p pd=50.52u as=13p ps=50.52u w=50u l=2u
X71 a_3038_14444# w_22220_9696# a_3108_27702# vdd pfet_03v3 ad=13p pd=50.52u as=13p ps=50.52u w=50u l=2u
X72 a_3038_14444# w_22220_9696# a_3108_27702# vdd pfet_03v3 ad=13p pd=50.52u as=32.5p ps=0.1013m w=50u l=2u
X73 a_10638_8600# w_27420_9696# a_2516_7200# vss nfet_03v3 ad=0.305p pd=2.22u as=0.305p ps=2.22u w=0.5u l=40u
X74 a_3108_27702# w_22220_9696# a_3038_14444# vdd pfet_03v3 ad=32.5p pd=0.1013m as=13p ps=50.52u w=50u l=2u
X75 a_3438_1504# vbn vss vss nfet_03v3 ad=4.16p pd=16.52u as=4.16p ps=16.52u w=16u l=4u
X76 a_3038_14444# a_3038_14444# vss vss nfet_03v3 ad=30.5p pd=0.10122m as=30.5p ps=0.10122m w=50u l=16u
X77 a_8438_27702# w_24820_9696# a_3108_27702# vdd pfet_03v3 ad=13p pd=50.52u as=13p ps=50.52u w=50u l=2u
X78 a_30138_7200# a_27338_7200# vdd vdd pfet_03v3 ad=1.3p pd=5.3u as=1.3p ps=5.3u w=2u l=0.5u
X79 vss vbn a_3438_1504# vss nfet_03v3 ad=4.16p pd=16.52u as=4.16p ps=16.52u w=16u l=4u
X80 a_27738_9800# a_24538_7200# out out pfet_03v3 ad=0.2166p pd=2.06u as=0.2166p ps=2.06u w=0.22u l=0.5u
X81 a_3108_27702# w_22220_9696# a_3038_14444# vdd pfet_03v3 ad=13p pd=50.52u as=13p ps=50.52u w=50u l=2u
X82 out vbn vss vss nfet_03v3 ad=4.16p pd=16.52u as=4.16p ps=16.52u w=16u l=4u
X83 vss vbn a_3438_1504# vss nfet_03v3 ad=4.16p pd=16.52u as=4.16p ps=16.52u w=16u l=4u
X84 vss vbn out vss nfet_03v3 ad=9.76p pd=33.22u as=4.16p ps=16.52u w=16u l=4u
X85 vss vbn a_3438_1504# vss nfet_03v3 ad=4.16p pd=16.52u as=4.16p ps=16.52u w=16u l=4u
X86 a_8438_27702# w_24820_9696# a_3108_27702# vdd pfet_03v3 ad=13p pd=50.52u as=13p ps=50.52u w=50u l=2u
X87 a_23038_7140# a_31867_10603# vss vss nfet_05v0 ad=0.3608p pd=2.52u as=0.2288p ps=1.58u w=0.82u l=0.6u
X88 a_3108_27702# w_24820_9696# a_8438_27702# vdd pfet_03v3 ad=13p pd=50.52u as=13p ps=50.52u w=50u l=2u
X89 a_3108_27702# w_24820_9696# a_8438_27702# vdd pfet_03v3 ad=32.5p pd=0.1013m as=13p ps=50.52u w=50u l=2u
X90 a_3438_1504# vbn vss vss nfet_03v3 ad=4.16p pd=16.52u as=4.16p ps=16.52u w=16u l=4u
X91 vdd a_3438_1504# a_3108_27702# vdd pfet_03v3 ad=32.5p pd=0.1013m as=13p ps=50.52u w=50u l=4u
X92 a_8438_27702# w_23620_9696# cap_mim_2f0_m4m5_noshield c_width=22u c_length=22u
X93 a_3438_1504# vbn vss vss nfet_03v3 ad=4.16p pd=16.52u as=4.16p ps=16.52u w=16u l=4u
X94 vss vbn a_3438_1504# vss nfet_03v3 ad=9.76p pd=33.22u as=4.16p ps=16.52u w=16u l=4u
X95 a_3108_27702# w_24820_9696# a_8438_27702# vdd pfet_03v3 ad=13p pd=50.52u as=13p ps=50.52u w=50u l=2u
X96 vss vbn a_3438_1504# vss nfet_03v3 ad=4.16p pd=16.52u as=4.16p ps=16.52u w=16u l=4u
X97 a_3108_27702# w_24820_9696# a_8438_27702# vdd pfet_03v3 ad=32.5p pd=0.1013m as=13p ps=50.52u w=50u l=2u
X98 a_10638_7200# vcmo a_2516_7200# vss nfet_03v3 ad=0.305p pd=2.22u as=0.305p ps=2.22u w=0.5u l=40u
X99 w_22220_9696# rec cap_mim_2f0_m4m5_noshield c_width=70.65u c_length=70.65u
X100 w_23620_9696# a_8438_27702# vss vss nfet_03v3 ad=13p pd=50.52u as=30.5p ps=0.10122m w=50u l=16u
X101 a_3438_1504# a_3438_1504# vdd vdd pfet_03v3 ad=13p pd=50.52u as=32.5p ps=0.1013m w=50u l=4u
X102 w_24820_9696# ref cap_mim_2f0_m4m5_noshield c_width=70.65u c_length=70.65u
X103 vss vbn a_3438_1504# vss nfet_03v3 ad=4.16p pd=16.52u as=4.16p ps=16.52u w=16u l=4u
X104 a_3108_27702# w_22220_9696# a_3038_14444# vdd pfet_03v3 ad=13p pd=50.52u as=13p ps=50.52u w=50u l=2u
X105 vss vbn a_3438_1504# vss nfet_03v3 ad=4.16p pd=16.52u as=4.16p ps=16.52u w=16u l=4u
X106 a_3038_14444# w_22220_9696# a_3108_27702# vdd pfet_03v3 ad=13p pd=50.52u as=13p ps=50.52u w=50u l=2u
X107 a_8438_27702# a_3038_14444# vss vss nfet_03v3 ad=30.5p pd=0.10122m as=30.5p ps=0.10122m w=50u l=16u
X108 a_3108_27702# w_22220_9696# a_3038_14444# vdd pfet_03v3 ad=13p pd=50.52u as=13p ps=50.52u w=50u l=2u
X109 a_3038_14444# w_22220_9696# a_3108_27702# vdd pfet_03v3 ad=13p pd=50.52u as=13p ps=50.52u w=50u l=2u
X110 a_3438_1504# vbn vss vss nfet_03v3 ad=4.16p pd=16.52u as=4.16p ps=16.52u w=16u l=4u
X111 a_32055_10603# a_30138_7200# a_31867_10603# vdd pfet_05v0 ad=0.1469p pd=1.085u as=0.2486p ps=2.01u w=0.565u l=0.5u
X112 a_25138_9800# a_22438_9664# vcm vcm pfet_03v3 ad=0.2166p pd=2.06u as=0.2166p ps=2.06u w=0.22u l=0.5u
X113 rec sw_rec_b vcm vss nfet_03v3 ad=0.61p pd=3.22u as=0.61p ps=3.22u w=1u l=0.5u
X114 out vbn vss vss nfet_03v3 ad=4.16p pd=16.52u as=9.76p ps=33.22u w=16u l=4u
X115 a_20838_8600# vbn vss vss nfet_03v3 ad=0.2128p pd=1.98u as=0.2128p ps=1.98u w=0.28u l=40u
X116 a_3038_14444# w_22220_9696# a_3108_27702# vdd pfet_03v3 ad=13p pd=50.52u as=13p ps=50.52u w=50u l=2u
X117 a_3438_1504# vbn vss vss nfet_03v3 ad=4.16p pd=16.52u as=4.16p ps=16.52u w=16u l=4u
X118 a_25138_9800# a_22438_9664# w_24820_9696# w_24820_9696# pfet_03v3 ad=0.2166p pd=2.06u as=0.2166p ps=2.06u w=0.22u l=0.5u
X119 a_24538_7200# a_23038_7140# vrs vss nfet_03v3 ad=0.305p pd=2.22u as=0.305p ps=2.22u w=0.5u l=0.5u
X120 a_10638_8600# a_10638_7200# vdd vdd pfet_03v3 ad=0.65p pd=3.3u as=0.65p ps=3.3u w=1u l=20u
C0 a_10638_7200# a_10638_8600# 0.95945f
C1 a_10638_7200# a_2516_7200# 0.18382f
C2 a_10638_7200# a_3438_1504# 1.305f
C3 a_10638_7200# out 0.9147f
C4 a_10638_7200# rst_amp 0.16138f
C5 a_10638_7200# sw_rec 0.10478f
C6 a_10638_7200# vbn 5.7718f
C7 a_10638_7200# vcmo 0.21798f
C8 a_10638_7200# vdd 13.697f
C9 a_10638_7200# vrs 0.16809f
C10 a_10638_7200# vss 7.6444f
C11 a_10638_7200# w_27420_9696# 0.19142f
C12 a_10638_8600# a_20838_8600# 7.5525f
C13 a_10638_8600# a_22438_9664# 0.07937f
C14 a_10638_8600# a_23038_7140# 0.06626f
C15 a_10638_8600# a_24538_7200# 0.53271f
C16 a_10638_8600# a_25138_9800# 0.01615f
C17 a_10638_8600# a_2516_7200# 0.14255f
C18 a_10638_8600# a_27338_7200# 0.09945f
C19 a_10638_8600# a_27738_9800# 0.16508f
C20 a_10638_8600# a_30138_7200# 0.49576f
C21 a_10638_8600# a_3438_1504# 0.07356f
C22 a_10638_8600# out 2.0268f
C23 a_10638_8600# rec 0.96567f
C24 a_10638_8600# ref 1.0952f
C25 a_10638_8600# sw_rec 0.52424f
C26 a_10638_8600# sw_rec_b 0.06673f
C27 a_10638_8600# vbn 1.7261f
C28 a_10638_8600# vcm 0.75393f
C29 a_10638_8600# vdd 2.7459f
C30 a_10638_8600# vg1 0.05634f
C31 a_10638_8600# vg2 0.09716f
C32 a_10638_8600# vss 38.08f
C33 a_10638_8600# w_22220_9696# 0.12489f
C34 a_10638_8600# w_23620_9696# 5.984f
C35 a_10638_8600# w_27420_9696# 2.785f
C36 a_19620_14444# a_3038_14444# 1.4782f
C37 a_19620_14444# a_8438_27702# 0.10832f
C38 a_19620_14444# vss 16.779f
C39 a_20838_8600# a_22438_9664# 0.29898f
C40 a_20838_8600# a_22538_9800# 0.33479f
C41 a_20838_8600# a_23038_7140# 2.3915f
C42 a_20838_8600# a_24538_7200# 0.56549f
C43 a_20838_8600# a_25138_9800# 0.2123f
C44 a_20838_8600# a_27116_7200# 0.59354f
C45 a_20838_8600# a_27338_7200# 2.1231f
C46 a_20838_8600# a_30138_7200# 0.19179f
C47 a_20838_8600# a_3438_1504# 0.07138f
C48 a_20838_8600# out 0.16685f
C49 a_20838_8600# rec 0.19932f
C50 a_20838_8600# ref 1.2737f
C51 a_20838_8600# sw_rec 2.6201f
C52 a_20838_8600# sw_rec_b 0.06935f
C53 a_20838_8600# vbn 0.07347f
C54 a_20838_8600# vcm 0.32578f
C55 a_20838_8600# vdd 3.6445f
C56 a_20838_8600# vg1 0.06459f
C57 a_20838_8600# vg2 0.21765f
C58 a_20838_8600# vss 19.081f
C59 a_20838_8600# w_22220_9696# 0.05957f
C60 a_20838_8600# w_23620_9696# 5.5354f
C61 a_20838_8600# w_27420_9696# 1.0962f
C62 a_21956_27642# a_23248_27642# 0.12734f
C63 a_21956_27642# a_3038_14444# 0.02475f
C64 a_21956_27642# a_3108_27702# 1.4958f
C65 a_21956_27642# a_3438_1504# 0.16305f
C66 a_21956_27642# vdd 16.305f
C67 a_21956_27642# vss 0.10012f
C68 a_21956_27642# w_23620_9696# 0.01007f
C69 a_21956_27642# w_24820_9696# 0.10783f
C70 a_22438_9664# a_22538_9800# 1.4847f
C71 a_22438_9664# a_23038_7140# 1.1803f
C72 a_22438_9664# a_24538_7200# 1.9692f
C73 a_22438_9664# a_25138_9800# 1.3174f
C74 a_22438_9664# a_27338_7200# 0.01695f
C75 a_22438_9664# a_27738_9800# 0.07812f
C76 a_22438_9664# a_30138_7200# 0.1453f
C77 a_22438_9664# a_3438_1504# 0.49904f
C78 a_22438_9664# out 0.2013f
C79 a_22438_9664# rec 0.22395f
C80 a_22438_9664# sw_rec 0.2137f
C81 a_22438_9664# sw_rec_b 0.07815f
C82 a_22438_9664# vcm 0.61444f
C83 a_22438_9664# vdd 0.40679f
C84 a_22438_9664# vg1 0.10644f
C85 a_22438_9664# vg2 0.21114f
C86 a_22438_9664# vrs 0.3519f
C87 a_22438_9664# vss 4.341f
C88 a_22438_9664# w_22220_9696# 0.3232f
C89 a_22438_9664# w_23620_9696# 0.53905f
C90 a_22438_9664# w_24820_9696# 0.35213f
C91 a_22438_9664# w_27420_9696# 0.31614f
C92 a_22538_9800# a_3438_1504# 0.09449f
C93 a_22538_9800# sw_rec 0.01315f
C94 a_22538_9800# vss 0.60875f
C95 a_22538_9800# w_22220_9696# 0.12794f
C96 a_22538_9800# w_23620_9696# 0.13091f
C97 a_23038_7140# a_24538_7200# 0.75011f
C98 a_23038_7140# a_27116_7200# 0.1038f
C99 a_23038_7140# a_27338_7200# 1.9453f
C100 a_23038_7140# a_30138_7200# 0.1409f
C101 a_23038_7140# a_31867_10603# 0.19373f
C102 a_23038_7140# a_3438_1504# 0.11297f
C103 a_23038_7140# out 0.05362f
C104 a_23038_7140# rec 0.45658f
C105 a_23038_7140# rst_amp 0.14032f
C106 a_23038_7140# sw_rec 0.54289f
C107 a_23038_7140# sw_rec_b 0.0265f
C108 a_23038_7140# vcm 0.67217f
C109 a_23038_7140# vdd 1.6816f
C110 a_23038_7140# vg1 1.6747f
C111 a_23038_7140# vg2 0.47823f
C112 a_23038_7140# vrs 0.78812f
C113 a_23038_7140# vss 2.5293f
C114 a_23038_7140# w_23620_9696# 0.09117f
C115 a_23248_27642# a_3108_27702# 0.09312f
C116 a_23248_27642# a_3438_1504# 0.79568f
C117 a_23248_27642# vdd 17.697f
C118 a_23248_27642# vss 0.10012f
C119 a_23248_27642# w_24820_9696# 0.31729f
C120 a_24538_7200# a_25138_9800# 0.14241f
C121 a_24538_7200# a_27116_7200# 0.02105f
C122 a_24538_7200# a_27338_7200# 0.04274f
C123 a_24538_7200# a_27738_9800# 1.3457f
C124 a_24538_7200# a_30138_7200# 0.32682f
C125 a_24538_7200# out 0.39698f
C126 a_24538_7200# rec 0.5834f
C127 a_24538_7200# sw_rec 0.27322f
C128 a_24538_7200# sw_rec_b 0.04823f
C129 a_24538_7200# vcm 0.37036f
C130 a_24538_7200# vdd 0.71237f
C131 a_24538_7200# vg1 0.06829f
C132 a_24538_7200# vg2 0.35952f
C133 a_24538_7200# vrs 0.05145f
C134 a_24538_7200# vss 2.775f
C135 a_24538_7200# w_23620_9696# 0.08332f
C136 a_24538_7200# w_27420_9696# 0.28958f
C137 a_2456_14444# a_3038_14444# 0.16385f
C138 a_2456_14444# sw_rec 0.17005f
C139 a_2456_14444# vss 18.261f
C140 a_25138_9800# sw_rec 0.01402f
C141 a_25138_9800# sw_rec_b 0.06531f
C142 a_25138_9800# vcm 0.20543f
C143 a_25138_9800# vss 0.58117f
C144 a_25138_9800# w_23620_9696# 0.01845f
C145 a_25138_9800# w_24820_9696# 0.12794f
C146 a_2516_7200# rec 0.0521f
C147 a_2516_7200# rst_amp 0.12938f
C148 a_2516_7200# sw_rec 0.46505f
C149 a_2516_7200# vbn 2.6407f
C150 a_2516_7200# vcmo 2.3132f
C151 a_2516_7200# vrs 4.4254f
C152 a_2516_7200# vss 3.9194f
C153 a_2516_7200# w_27420_9696# 0.30925f
C154 a_2648_27642# a_3038_14444# 0.02381f
C155 a_2648_27642# a_3108_27702# 1.4341f
C156 a_2648_27642# sw_rec 0.13804f
C157 a_2648_27642# vdd 16.529f
C158 a_2648_27642# vss 0.26226f
C159 a_2648_27642# w_22220_9696# 0.15966f
C160 a_27116_7200# a_27338_7200# 0.0976f
C161 a_27116_7200# out 0.19489f
C162 a_27116_7200# rec 0.40545f
C163 a_27116_7200# sw_rec 0.62595f
C164 a_27116_7200# vcm 0.66199f
C165 a_27116_7200# vss 1.0642f
C166 a_27338_7200# a_30138_7200# 0.95011f
C167 a_27338_7200# out 0.0792f
C168 a_27338_7200# rec 0.69924f
C169 a_27338_7200# sw_rec 0.76687f
C170 a_27338_7200# vcm 0.02784f
C171 a_27338_7200# vdd 3.2876f
C172 a_27338_7200# vg2 0.01666f
C173 a_27338_7200# vss 3.0922f
C174 a_27738_9800# out 0.24623f
C175 a_27738_9800# sw_rec 0.01202f
C176 a_27738_9800# vss 0.66303f
C177 a_27738_9800# w_23620_9696# 0.01397f
C178 a_27738_9800# w_27420_9696# 0.12804f
C179 a_30138_7200# a_31867_10603# 0.58604f
C180 a_30138_7200# out 0.07305f
C181 a_30138_7200# rec 0.10768f
C182 a_30138_7200# rst_amp 0.41587f
C183 a_30138_7200# sw_rec 0.8531f
C184 a_30138_7200# vcm 1.6179f
C185 a_30138_7200# vdd 3.2908f
C186 a_30138_7200# vg1 0.10801f
C187 a_30138_7200# vg2 0.07791f
C188 a_30138_7200# vss 3.0632f
C189 a_30138_7200# w_23620_9696# 0.26897f
C190 a_30138_7200# w_27420_9696# 0.3441f
C191 a_3038_14444# a_3108_27702# 17.009f
C192 a_3038_14444# a_8438_27702# 9.3235f
C193 a_3038_14444# rec 1.6276f
C194 a_3038_14444# sw_rec_b 0.28842f
C195 a_3038_14444# vdd 3.0855f
C196 a_3038_14444# vss 36.362f
C197 a_3038_14444# w_22220_9696# 31.669f
C198 a_3038_14444# w_23620_9696# 2.2327f
C199 a_3038_14444# w_24820_9696# 1.1444f
C200 a_30932_27642# vdd 17.996f
C201 a_30932_27642# vss 0.25879f
C202 a_30932_27642# w_23620_9696# 0.2111f
C203 a_30932_27642# w_27420_9696# 0.33594f
C204 a_3108_27702# a_3438_1504# 5.8928f
C205 a_3108_27702# a_8438_27702# 17.056f
C206 a_3108_27702# rec 0.51798f
C207 a_3108_27702# sw_rec_b 0.61337f
C208 a_3108_27702# vcm 2.2962f
C209 a_3108_27702# vdd 23.489f
C210 a_3108_27702# vss 2.4756f
C211 a_3108_27702# w_22220_9696# 27.542f
C212 a_3108_27702# w_24820_9696# 28.335f
C213 a_31867_10603# rst_amp 0.52526f
C214 a_31867_10603# vdd 0.48616f
C215 a_31867_10603# vg1 0.02873f
C216 a_31867_10603# vss 0.50616f
C217 a_31867_10603# w_23620_9696# 0.01767f
C218 a_3438_1504# a_8438_27702# 1.901f
C219 a_3438_1504# out 1.2485f
C220 a_3438_1504# rec 0.08185f
C221 a_3438_1504# rst_amp 0.08735f
C222 a_3438_1504# sw_rec 0.0871f
C223 a_3438_1504# sw_rec_b 1.4578f
C224 a_3438_1504# vbn 22.708f
C225 a_3438_1504# vcm 1.338f
C226 a_3438_1504# vdd 21.896f
C227 a_3438_1504# vrs 0.10663f
C228 a_3438_1504# vss 13.508f
C229 a_3438_1504# w_22220_9696# 0.02008f
C230 a_3438_1504# w_23620_9696# 7.0108f
C231 a_3438_1504# w_24820_9696# 5.1733f
C232 a_3438_1504# w_27420_9696# 0.30609f
C233 a_8438_27702# out 2.5035f
C234 a_8438_27702# rec 0.59982f
C235 a_8438_27702# sw_rec_b 2.2396f
C236 a_8438_27702# vcm 2.6023f
C237 a_8438_27702# vdd 3.9805f
C238 a_8438_27702# vg1 1.8639f
C239 a_8438_27702# vg2 2.5209f
C240 a_8438_27702# vss 46.156f
C241 a_8438_27702# w_22220_9696# 0.09749f
C242 a_8438_27702# w_23620_9696# 13.664f
C243 a_8438_27702# w_24820_9696# 31.95f
C244 a_8438_27702# w_27420_9696# 1.677f
C245 out rec 0.08665f
C246 out ref 1.1124f
C247 out rst_amp 0.09271f
C248 out sw_rec 0.09062f
C249 out vbn 4.791f
C250 out vcm 0.089018f
C251 out vdd 12.336f
C252 out vg1 0.09008f
C253 out vg2 9.4819f
C254 out vss 20.19f
C255 out w_23620_9696# 2.1816f
C256 out w_24820_9696# 0.03622f
C257 out w_27420_9696# 1.3254f
C258 rec ref 7.3627f
C259 rec rst_amp 0.11333f
C260 rec sw_rec 2.2574f
C261 rec sw_rec_b 0.81335f
C262 rec vbn 0.26937f
C263 rec vcm 2.053f
C264 rec vcmo 0.04633f
C265 rec vdd 2.0453f
C266 rec vg1 0.23449f
C267 rec vg2 0.24298f
C268 rec vrs 0.57077f
C269 rec vss 101.31f
C270 rec w_22220_9696# 13.406f
C271 rec w_23620_9696# 0.087123f
C272 rec w_24820_9696# 3.0713f
C273 rec w_27420_9696# 0.10929f
C274 ref rst_amp 0.15885f
C275 ref sw_rec 1.6086f
C276 ref sw_rec_b 0.17584f
C277 ref vbn 0.53201f
C278 ref vcm 1.3353f
C279 ref vcmo 0.68451f
C280 ref vdd 1.9439f
C281 ref vg1 0.53441f
C282 ref vg2 0.75731f
C283 ref vrs 0.44961f
C284 ref vss 104.35f
C285 ref w_22220_9696# 0.30141f
C286 ref w_23620_9696# 0.41624f
C287 ref w_24820_9696# 16.055f
C288 ref w_27420_9696# 2.1384f
C289 rst_amp sw_rec 0.07648f
C290 rst_amp sw_rec_b 11.631f
C291 rst_amp vbn 21.46f
C292 rst_amp vcm 0.094114f
C293 rst_amp vcmo 1.4231f
C294 rst_amp vdd 0.95591f
C295 rst_amp vg1 0.10293f
C296 rst_amp vrs 0.07441f
C297 rst_amp vss 15.655f
C298 rst_amp w_22220_9696# 0.13773f
C299 rst_amp w_23620_9696# 0.12577f
C300 rst_amp w_24820_9696# 0.10836f
C301 rst_amp w_27420_9696# 2.2547f
C302 sw_rec sw_rec_b 0.17488f
C303 sw_rec vbn 0.71996f
C304 sw_rec vcm 1.2057f
C305 sw_rec vcmo 0.33826f
C306 sw_rec vdd 3.8698f
C307 sw_rec vg1 0.0783f
C308 sw_rec vg2 0.08601f
C309 sw_rec vrs 23.75f
C310 sw_rec vss 19.898f
C311 sw_rec w_22220_9696# 0.22355f
C312 sw_rec w_23620_9696# 0.0059022f
C313 sw_rec w_24820_9696# 0.21949f
C314 sw_rec w_27420_9696# 0.28568f
C315 sw_rec_b vbn 0.34958f
C316 sw_rec_b vcm 1.4274f
C317 sw_rec_b vcmo 0.07433f
C318 sw_rec_b vdd 2.8598f
C319 sw_rec_b vrs 0.07403f
C320 sw_rec_b vss 16.722f
C321 sw_rec_b w_22220_9696# 0.22694f
C322 sw_rec_b w_23620_9696# 2.3718f
C323 sw_rec_b w_24820_9696# 0.82544f
C324 sw_rec_b w_27420_9696# 0.09025f
C325 vbn vcm 0.17305f
C326 vbn vcmo 23.198f
C327 vbn vdd 0.01831f
C328 vbn vg1 0.03534f
C329 vbn vrs 1.668f
C330 vbn vss 91.963f
C331 vbn w_22220_9696# 0.06373f
C332 vbn w_24820_9696# 0.02917f
C333 vbn w_27420_9696# 0.24987f
C334 vcm vcmo 11.9f
C335 vcm vdd 1.9931f
C336 vcm vg1 0.29927f
C337 vcm vg2 0.11899f
C338 vcm vrs 11.908f
C339 vcm vss 22.062f
C340 vcm w_22220_9696# 0.44842f
C341 vcm w_23620_9696# 0.43466f
C342 vcm w_24820_9696# 1.8786f
C343 vcm w_27420_9696# 0.37043f
C344 vcmo vdd 0.02435f
C345 vcmo vg1 0.07295f
C346 vcmo vg2 0.04044f
C347 vcmo vrs 7.0255f
C348 vcmo vss 26.481f
C349 vcmo w_22220_9696# 0.08096f
C350 vcmo w_24820_9696# 0.04315f
C351 vcmo w_27420_9696# 1.3549f
C352 vdd vg1 3.5021f
C353 vdd vg2 4.603f
C354 vdd vrs 0.04827f
C355 vdd vss 1354.7f
C356 vdd w_22220_9696# 11.319f
C357 vdd w_23620_9696# 6.532f
C358 vdd w_24820_9696# 11.708f
C359 vdd w_27420_9696# 3.4056f
C360 vg1 vg2 2.5518f
C361 vg1 vrs 0.06302f
C362 vg1 vss 23.52f
C363 vg1 w_23620_9696# 0.45995f
C364 vg1 w_24820_9696# 0.99954f
C365 vg1 w_27420_9696# 5.1071f
C366 vg2 vrs 0.09784f
C367 vg2 vss 23.194f
C368 vg2 w_23620_9696# 0.981f
C369 vg2 w_27420_9696# 0.23607f
C370 vrs vss 10.159f
C371 vrs w_22220_9696# 0.15559f
C372 vrs w_24820_9696# 0.15287f
C373 vss w_22220_9696# 19.86f
C374 vss w_23620_9696# 45.092f
C375 vss w_24820_9696# 20.409f
C376 vss w_27420_9696# 47.993f
C377 w_22220_9696# w_23620_9696# 1.4231f
C378 w_22220_9696# w_24820_9696# 11.487f
C379 w_22220_9696# w_27420_9696# 0.53433f
C380 w_23620_9696# w_24820_9696# 2.323f
C381 w_23620_9696# w_27420_9696# 3.7596f
C382 w_24820_9696# w_27420_9696# 0.58887f
.ends
