* NGSPICE file created from TGATE (flattened) - technology: gf180mcuD

.subckt TGATE VDD VSS IN OUT C CBAR
X0 OUT CBAR IN VDD pfet_05v0 ad=1.2078p pd=4.42u as=1.1712p ps=4.36u w=1.22u l=0.6u
X1 OUT C IN VSS nfet_05v0 ad=0.5876p pd=3.21u as=0.5424p ps=3.05u w=0.565u l=0.6u
C0 OUT C 0.09856f
C1 CBAR OUT 0.10844f
C2 CBAR VDD 0.1805f
C3 OUT VDD 0.2089f
C4 IN C 0.09674f
C5 CBAR IN 0.10623f
C6 CBAR C 0.11282f
C7 IN OUT 0.10392f
C8 IN VDD 0.14111f
C9 C VSS 0.19557f
C10 OUT VSS 0.15506f
C11 IN VSS 0.17946f
C12 CBAR VSS 0.03351f
C13 VDD VSS 1.97074f
.ends
