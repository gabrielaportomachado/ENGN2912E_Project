* NGSPICE file created from amp_ch (flattened) - technology: gf180mcuD
* MIM correction of flow.py pex: capacitance to the layers below that Magic attached to MIM TOP plates was moved to the bottom plates:
*   a_28022_1954#: 8.67 fF -> vss; a_40238_24600#: 16.16 fF -> vss; a_6838_13302#: 4.21 fF -> w_6420_25696#; w_28620_25696#: 59.31 fF -> ref + vcm; w_39820_39896#: 13.62 fF -> out + w_6420_25696#; w_5020_25696#: 59.82 fF -> rec + w_6420_25696#
.subckt amp_ch rec ref vbn vcm vg1 vcmo vg2 vrs out sw_rec sw_rec_b rst_amp  vdd vss
X0 w_6420_25696# a_6838_13302# vss vss nfet_03v3 ad=13p pd=50.52u as=13p ps=50.52u w=50u l=16u
X1 vss vbn a_21038_6704# vss nfet_03v3 ad=4.16p pd=16.52u as=4.16p ps=16.52u w=16u l=4u
X2 a_2255_26003# a_2135_25448# a_2067_26003# vdd pfet_05v0 ad=0.1469p pd=1.085u as=0.2486p ps=2.01u w=0.565u l=0.5u
X3 a_21038_6704# vbn vss vss nfet_03v3 ad=4.16p pd=16.52u as=4.16p ps=16.52u w=16u l=4u
X4 a_1508_13302# w_5020_25696# a_1438_1244# vdd pfet_03v3 ad=13p pd=50.52u as=13p ps=50.52u w=50u l=2u
X5 a_40438_43940# sw_rec a_40316_41200# vss nfet_03v3 ad=0.61p pd=3.22u as=0.61p ps=3.22u w=1u l=0.5u
X6 a_5238_25664# a_2731_25872# vrs vss nfet_03v3 ad=0.305p pd=2.22u as=0.305p ps=2.22u w=0.5u l=0.5u
X7 a_21038_6704# vbn vss vss nfet_03v3 ad=4.16p pd=16.52u as=4.16p ps=16.52u w=16u l=4u
X8 vss vbn a_21038_6704# vss nfet_03v3 ad=4.16p pd=16.52u as=4.16p ps=16.52u w=16u l=4u
X9 a_1438_1244# w_5020_25696# a_1508_13302# vdd pfet_03v3 ad=13p pd=50.52u as=13p ps=50.52u w=50u l=2u
X10 a_1438_1244# w_5020_25696# a_1508_13302# vdd pfet_03v3 ad=13p pd=50.52u as=32.5p ps=0.1013m w=50u l=2u
X11 a_1508_13302# a_21038_6704# vdd vdd pfet_03v3 ad=13p pd=50.52u as=13p ps=50.52u w=50u l=4u
X12 vss vbn a_21038_6704# vss nfet_03v3 ad=9.76p pd=33.22u as=4.16p ps=16.52u w=16u l=4u
X13 out vbn vss vss nfet_03v3 ad=4.16p pd=16.52u as=9.76p ps=33.22u w=16u l=4u
X14 a_40138_40000# a_14738_25200# w_39820_39896# w_39820_39896# pfet_03v3 ad=0.2166p pd=2.06u as=0.2166p ps=2.06u w=0.22u l=0.5u
X15 vdd a_28022_1954# out vss nfet_06v0_nvt ad=5.7p pd=21.14u as=5.7p ps=21.14u w=10u l=2u
X16 a_6838_13302# a_1438_1244# vss vss nfet_03v3 ad=30.5p pd=0.10122m as=30.5p ps=0.10122m w=50u l=16u
X17 vss vbn a_21038_6704# vss nfet_03v3 ad=4.16p pd=16.52u as=4.16p ps=16.52u w=16u l=4u
X18 w_5020_25696# rec cap_mim_2f0_m4m5_noshield c_width=61.15u c_length=61.15u
X19 a_6838_13302# w_28620_25696# a_1508_13302# vdd pfet_03v3 ad=13p pd=50.52u as=13p ps=50.52u w=50u l=2u
X20 a_6838_13302# w_28620_25696# a_1508_13302# vdd pfet_03v3 ad=13p pd=50.52u as=32.5p ps=0.1013m w=50u l=2u
X21 a_1508_13302# w_28620_25696# a_6838_13302# vdd pfet_03v3 ad=13p pd=50.52u as=13p ps=50.52u w=50u l=2u
X22 vss vbn a_21038_6704# vss nfet_03v3 ad=4.16p pd=16.52u as=4.16p ps=16.52u w=16u l=4u
X23 rec sw_rec_b vcm vss nfet_03v3 ad=0.61p pd=3.22u as=0.61p ps=3.22u w=1u l=0.5u
X24 a_21038_6704# vbn vss vss nfet_03v3 ad=4.16p pd=16.52u as=4.16p ps=16.52u w=16u l=4u
X25 vdd a_21038_6704# a_21038_6704# vdd pfet_03v3 ad=13p pd=50.52u as=13p ps=50.52u w=50u l=4u
X26 a_28022_1954# w_39820_39896# a_36238_23200# vss nfet_03v3 ad=0.305p pd=2.22u as=0.305p ps=2.22u w=0.5u l=40u
X27 a_6838_13302# w_28620_25696# a_1508_13302# vdd pfet_03v3 ad=13p pd=50.52u as=13p ps=50.52u w=50u l=2u
X28 a_6838_13302# w_28620_25696# a_1508_13302# vdd pfet_03v3 ad=13p pd=50.52u as=32.5p ps=0.1013m w=50u l=2u
X29 a_5338_25800# a_5238_25664# w_5020_25696# w_5020_25696# pfet_03v3 ad=0.2166p pd=2.06u as=0.2166p ps=2.06u w=0.22u l=0.5u
X30 a_1508_13302# w_28620_25696# a_6838_13302# vdd pfet_03v3 ad=13p pd=50.52u as=13p ps=50.52u w=50u l=2u
X31 a_1508_13302# w_28620_25696# a_6838_13302# vdd pfet_03v3 ad=13p pd=50.52u as=13p ps=50.52u w=50u l=2u
X32 a_40238_24600# sw_rec vdd vdd pfet_03v3 ad=0.65p pd=3.3u as=0.65p ps=3.3u w=1u l=0.5u
X33 a_21038_6704# vbn vss vss nfet_03v3 ad=4.16p pd=16.52u as=4.16p ps=16.52u w=16u l=4u
X34 vss vbn a_21038_6704# vss nfet_03v3 ad=4.16p pd=16.52u as=4.16p ps=16.52u w=16u l=4u
X35 a_21038_6704# vbn vss vss nfet_03v3 ad=4.16p pd=16.52u as=4.16p ps=16.52u w=16u l=4u
X36 w_39820_39896# out cap_mim_2f0_m4m5_noshield c_width=11.92u c_length=11.92u
X37 w_28620_25696# ref cap_mim_2f0_m4m5_noshield c_width=61.15u c_length=61.15u
X38 a_1438_1244# w_5020_25696# a_1508_13302# vdd pfet_03v3 ad=13p pd=50.52u as=13p ps=50.52u w=50u l=2u
X39 a_1438_1244# w_5020_25696# a_1508_13302# vdd pfet_03v3 ad=13p pd=50.52u as=32.5p ps=0.1013m w=50u l=2u
X40 a_6838_13302# a_1438_1244# vss vss nfet_03v3 ad=30.5p pd=0.10122m as=30.5p ps=0.10122m w=50u l=16u
X41 a_40238_24600# vbn vss vss nfet_03v3 ad=0.2128p pd=1.98u as=0.2128p ps=1.98u w=0.28u l=40u
X42 a_1508_13302# w_5020_25696# a_1438_1244# vdd pfet_03v3 ad=32.5p pd=0.1013m as=13p ps=50.52u w=50u l=2u
X43 a_1508_13302# w_5020_25696# a_1438_1244# vdd pfet_03v3 ad=13p pd=50.52u as=13p ps=50.52u w=50u l=2u
X44 a_1508_13302# w_28620_25696# a_6838_13302# vdd pfet_03v3 ad=13p pd=50.52u as=13p ps=50.52u w=50u l=2u
X45 w_6420_25696# a_6838_13302# vss vss nfet_03v3 ad=13p pd=50.52u as=30.5p ps=0.10122m w=50u l=16u
X46 a_2731_25872# a_2067_26003# vdd vdd pfet_05v0 ad=0.5368p pd=3.32u as=0.38705p ps=2.08u w=1.22u l=0.5u
X47 w_28620_25696# ref cap_mim_2f0_m4m5_noshield c_width=61.15u c_length=61.15u
X48 a_5238_25664# a_2731_25872# vg1 vdd pfet_03v3 ad=0.325p pd=2.3u as=0.325p ps=2.3u w=0.5u l=0.5u
X49 w_39820_39896# w_6420_25696# cap_mim_2f0_m4m5_noshield c_width=38.59u c_length=38.59u
X50 vss vbn a_21038_6704# vss nfet_03v3 ad=4.16p pd=16.52u as=4.16p ps=16.52u w=16u l=4u
X51 a_21038_6704# vbn vss vss nfet_03v3 ad=4.16p pd=16.52u as=4.16p ps=16.52u w=16u l=4u
X52 a_1508_13302# w_5020_25696# a_1438_1244# vdd pfet_03v3 ad=13p pd=50.52u as=13p ps=50.52u w=50u l=2u
X53 a_1508_13302# w_5020_25696# a_1438_1244# vdd pfet_03v3 ad=13p pd=50.52u as=13p ps=50.52u w=50u l=2u
X54 a_1438_1244# w_5020_25696# a_1508_13302# vdd pfet_03v3 ad=13p pd=50.52u as=13p ps=50.52u w=50u l=2u
X55 a_21038_6704# vbn vss vss nfet_03v3 ad=4.16p pd=16.52u as=4.16p ps=16.52u w=16u l=4u
X56 a_6838_13302# w_28620_25696# a_1508_13302# vdd pfet_03v3 ad=13p pd=50.52u as=13p ps=50.52u w=50u l=2u
X57 vss vbn out vss nfet_03v3 ad=4.16p pd=16.52u as=4.16p ps=16.52u w=16u l=4u
X58 a_2135_25448# a_40438_43940# vdd vdd pfet_03v3 ad=1.3p pd=5.3u as=1.3p ps=5.3u w=2u l=0.5u
X59 a_1508_13302# w_28620_25696# a_6838_13302# vdd pfet_03v3 ad=32.5p pd=0.1013m as=13p ps=50.52u w=50u l=2u
X60 w_5020_25696# rec cap_mim_2f0_m4m5_noshield c_width=61.15u c_length=61.15u
X61 vss vbn a_21038_6704# vss nfet_03v3 ad=4.16p pd=16.52u as=4.16p ps=16.52u w=16u l=4u
X62 a_21038_6704# vbn vss vss nfet_03v3 ad=4.16p pd=16.52u as=4.16p ps=16.52u w=16u l=4u
X63 a_2067_26003# a_2135_25448# vss vss nfet_05v0 ad=93.59999f pd=0.88u as=0.1584p ps=1.6u w=0.36u l=0.6u
X64 vss a_6838_13302# w_6420_25696# vss nfet_03v3 ad=30.5p pd=0.10122m as=13p ps=50.52u w=50u l=16u
X65 vss vbn a_21038_6704# vss nfet_03v3 ad=4.16p pd=16.52u as=4.16p ps=16.52u w=16u l=4u
X66 vss a_6838_13302# w_6420_25696# vss nfet_03v3 ad=13p pd=50.52u as=13p ps=50.52u w=50u l=16u
X67 vdd a_21038_6704# w_6420_25696# vdd pfet_03v3 ad=32.5p pd=0.1013m as=13p ps=50.52u w=50u l=4u
X68 a_6838_13302# w_28620_25696# a_1508_13302# vdd pfet_03v3 ad=13p pd=50.52u as=13p ps=50.52u w=50u l=2u
X69 a_36238_23200# vbn vss vss nfet_03v3 ad=0.61p pd=3.22u as=0.61p ps=3.22u w=1u l=20u
X70 a_1508_13302# w_28620_25696# a_6838_13302# vdd pfet_03v3 ad=32.5p pd=0.1013m as=13p ps=50.52u w=50u l=2u
X71 a_1508_13302# w_28620_25696# a_6838_13302# vdd pfet_03v3 ad=13p pd=50.52u as=13p ps=50.52u w=50u l=2u
X72 a_2135_25448# a_40438_43940# vss vss nfet_03v3 ad=0.61p pd=3.22u as=0.61p ps=3.22u w=1u l=0.5u
X73 a_21038_6704# a_21038_6704# vdd vdd pfet_03v3 ad=13p pd=50.52u as=32.5p ps=0.1013m w=50u l=4u
X74 out vbn vss vss nfet_03v3 ad=4.16p pd=16.52u as=4.16p ps=16.52u w=16u l=4u
X75 a_1438_1244# w_5020_25696# a_1508_13302# vdd pfet_03v3 ad=13p pd=50.52u as=13p ps=50.52u w=50u l=2u
X76 a_28022_1954# a_37038_1140# vdd vdd pfet_03v3 ad=0.65p pd=3.3u as=0.65p ps=3.3u w=1u l=20u
X77 a_1438_1244# a_1438_1244# vss vss nfet_03v3 ad=30.5p pd=0.10122m as=30.5p ps=0.10122m w=50u l=16u
X78 a_1508_13302# w_5020_25696# a_1438_1244# vdd pfet_03v3 ad=32.5p pd=0.1013m as=13p ps=50.52u w=50u l=2u
X79 vss vbn a_21038_6704# vss nfet_03v3 ad=4.16p pd=16.52u as=4.16p ps=16.52u w=16u l=4u
X80 vdd rst_amp a_2255_26003# vdd pfet_05v0 ad=0.38705p pd=2.08u as=0.1469p ps=1.085u w=0.565u l=0.5u
X81 a_1508_13302# w_28620_25696# a_6838_13302# vdd pfet_03v3 ad=13p pd=50.52u as=13p ps=50.52u w=50u l=2u
X82 vss rst_amp a_2067_26003# vss nfet_05v0 ad=0.2288p pd=1.58u as=93.59999f ps=0.88u w=0.36u l=0.6u
X83 vss vbn out vss nfet_03v3 ad=4.16p pd=16.52u as=4.16p ps=16.52u w=16u l=4u
X84 a_21038_6704# vbn vss vss nfet_03v3 ad=4.16p pd=16.52u as=4.16p ps=16.52u w=16u l=4u
X85 vss vbn a_21038_6704# vss nfet_03v3 ad=4.16p pd=16.52u as=4.16p ps=16.52u w=16u l=4u
X86 a_37038_1140# vcmo a_36238_23200# vss nfet_03v3 ad=0.305p pd=2.22u as=0.305p ps=2.22u w=0.5u l=40u
X87 a_14738_25200# a_2731_25872# vrs vss nfet_03v3 ad=0.305p pd=2.22u as=0.305p ps=2.22u w=0.5u l=0.5u
X88 a_21038_6704# vbn vss vss nfet_03v3 ad=4.16p pd=16.52u as=9.76p ps=33.22u w=16u l=4u
X89 w_6420_25696# a_21038_6704# vdd vdd pfet_03v3 ad=13p pd=50.52u as=13p ps=50.52u w=50u l=4u
X90 a_21038_6704# vbn vss vss nfet_03v3 ad=4.16p pd=16.52u as=4.16p ps=16.52u w=16u l=4u
X91 a_28938_25800# a_5238_25664# vcm vcm pfet_03v3 ad=0.2166p pd=2.06u as=0.2166p ps=2.06u w=0.22u l=0.5u
X92 a_40138_40000# a_14738_25200# out out pfet_03v3 ad=0.2166p pd=2.06u as=0.2166p ps=2.06u w=0.22u l=0.5u
X93 a_28022_1954# w_39820_39896# a_36238_23200# vss nfet_03v3 ad=0.305p pd=2.22u as=0.305p ps=2.22u w=0.5u l=40u
X94 a_28022_1954# vss cap_mim_2f0_m4m5_noshield c_width=31.465u c_length=31.465u
X95 a_1508_13302# w_5020_25696# a_1438_1244# vdd pfet_03v3 ad=13p pd=50.52u as=13p ps=50.52u w=50u l=2u
X96 a_40238_24600# vss cap_mim_2f0_m4m5_noshield c_width=44.595u c_length=44.595u
X97 a_1438_1244# w_5020_25696# a_1508_13302# vdd pfet_03v3 ad=13p pd=50.52u as=13p ps=50.52u w=50u l=2u
X98 a_40438_43940# a_40238_24600# vdd vdd pfet_03v3 ad=0.65p pd=3.3u as=0.65p ps=3.3u w=1u l=0.5u
X99 a_1438_1244# a_1438_1244# vss vss nfet_03v3 ad=30.5p pd=0.10122m as=30.5p ps=0.10122m w=50u l=16u
X100 out vbn vss vss nfet_03v3 ad=4.16p pd=16.52u as=4.16p ps=16.52u w=16u l=4u
X101 a_40316_41200# a_40238_24600# vss vss nfet_03v3 ad=0.61p pd=3.22u as=0.61p ps=3.22u w=1u l=0.5u
X102 a_28938_25800# a_5238_25664# w_28620_25696# w_28620_25696# pfet_03v3 ad=0.2166p pd=2.06u as=0.2166p ps=2.06u w=0.22u l=0.5u
X103 a_6838_13302# w_28620_25696# a_1508_13302# vdd pfet_03v3 ad=13p pd=50.52u as=13p ps=50.52u w=50u l=2u
X104 vdd a_21038_6704# a_1508_13302# vdd pfet_03v3 ad=13p pd=50.52u as=13p ps=50.52u w=50u l=4u
X105 w_28620_25696# vcm cap_mim_2f0_m4m5_noshield c_width=8.45u c_length=8.45u
X106 a_37038_1140# vcmo a_36238_23200# vss nfet_03v3 ad=0.305p pd=2.22u as=0.305p ps=2.22u w=0.5u l=40u
X107 a_5338_25800# a_5238_25664# w_6420_25696# w_6420_25696# pfet_03v3 ad=0.2166p pd=2.06u as=0.2166p ps=2.06u w=0.22u l=0.5u
X108 a_6838_13302# w_6420_25696# cap_mim_2f0_m4m5_noshield c_width=22u c_length=22u
X109 a_2731_25872# a_2067_26003# vss vss nfet_05v0 ad=0.3608p pd=2.52u as=0.2288p ps=1.58u w=0.82u l=0.6u
X110 a_6838_13302# w_28620_25696# a_1508_13302# vdd pfet_03v3 ad=13p pd=50.52u as=13p ps=50.52u w=50u l=2u
X111 a_21038_6704# vbn vss vss nfet_03v3 ad=4.16p pd=16.52u as=4.16p ps=16.52u w=16u l=4u
X112 w_5020_25696# w_6420_25696# cap_mim_2f0_m4m5_noshield c_width=8.45u c_length=8.45u
X113 a_37038_1140# a_37038_1140# vdd vdd pfet_03v3 ad=0.65p pd=3.3u as=0.65p ps=3.3u w=1u l=20u
X114 rec sw_rec vcm vdd pfet_03v3 ad=1.3p pd=5.3u as=1.3p ps=5.3u w=2u l=0.5u
X115 vss vbn out vss nfet_03v3 ad=9.76p pd=33.22u as=4.16p ps=16.52u w=16u l=4u
X116 vss vbn a_21038_6704# vss nfet_03v3 ad=4.16p pd=16.52u as=4.16p ps=16.52u w=16u l=4u
X117 a_1438_1244# w_5020_25696# a_1508_13302# vdd pfet_03v3 ad=13p pd=50.52u as=13p ps=50.52u w=50u l=2u
X118 a_1508_13302# w_5020_25696# a_1438_1244# vdd pfet_03v3 ad=13p pd=50.52u as=13p ps=50.52u w=50u l=2u
X119 a_40438_43940# sw_rec vdd vdd pfet_03v3 ad=0.65p pd=3.3u as=0.65p ps=3.3u w=1u l=0.5u
X120 a_14738_25200# a_2731_25872# vg2 vdd pfet_03v3 ad=0.325p pd=2.3u as=0.325p ps=2.3u w=0.5u l=0.5u
C0 a_1048_13242# a_1438_1244# 0.02381f
C1 a_1048_13242# a_1508_13302# 1.4341f
C2 a_1048_13242# vdd 16.714f
C3 a_1048_13242# vrs 0.01283f
C4 a_1048_13242# vss 0.31945f
C5 a_1048_13242# w_5020_25696# 0.15962f
C6 a_1438_1244# a_1508_13302# 17.76f
C7 a_1438_1244# a_18020_1244# 1.4894f
C8 a_1438_1244# a_20356_13242# 0.02475f
C9 a_1438_1244# a_6838_13302# 5.6588f
C10 a_1438_1244# a_856_1244# 0.16385f
C11 a_1438_1244# vbn 0.47766f
C12 a_1438_1244# vdd 2.4541f
C13 a_1438_1244# vrs 0.04403f
C14 a_1438_1244# vss 37.547f
C15 a_1438_1244# w_28620_25696# 0.72194f
C16 a_1438_1244# w_5020_25696# 32.163f
C17 a_1438_1244# w_6420_25696# 0.97868f
C18 a_14738_25200# a_2135_25448# 0.3256f
C19 a_14738_25200# a_2731_25872# 1.9367f
C20 a_14738_25200# a_28022_1954# 0.51438f
C21 a_14738_25200# a_28938_25800# 0.01038f
C22 a_14738_25200# a_36238_23200# 0.18055f
C23 a_14738_25200# a_37038_1140# 0.16523f
C24 a_14738_25200# a_40138_40000# 1.3219f
C25 a_14738_25200# a_40238_24600# 0.01232f
C26 a_14738_25200# a_40316_41200# 0.01656f
C27 a_14738_25200# a_5238_25664# 0.28457f
C28 a_14738_25200# out 1.7297f
C29 a_14738_25200# rec 0.19704f
C30 a_14738_25200# ref 0.31179f
C31 a_14738_25200# sw_rec 5.2237f
C32 a_14738_25200# sw_rec_b 0.14262f
C33 a_14738_25200# vbn 0.08652f
C34 a_14738_25200# vcm 1.0661f
C35 a_14738_25200# vcmo 0.13922f
C36 a_14738_25200# vdd 1.1364f
C37 a_14738_25200# vg1 0.54827f
C38 a_14738_25200# vg2 0.33147f
C39 a_14738_25200# vrs 0.03652f
C40 a_14738_25200# vss 8.7091f
C41 a_14738_25200# w_28620_25696# 0.62156f
C42 a_14738_25200# w_39820_39896# 1.3015f
C43 a_14738_25200# w_6420_25696# 1.4326f
C44 a_1508_13302# a_20356_13242# 1.4958f
C45 a_1508_13302# a_21038_6704# 7.247f
C46 a_1508_13302# a_21648_13242# 0.16221f
C47 a_1508_13302# a_6838_13302# 17.938f
C48 a_1508_13302# vbn 0.51891f
C49 a_1508_13302# vdd 24.165f
C50 a_1508_13302# vss 2.9123f
C51 a_1508_13302# w_28620_25696# 28.587f
C52 a_1508_13302# w_5020_25696# 26.862f
C53 a_1508_13302# w_6420_25696# 0.50953f
C54 a_18020_1244# vbn 0.04867f
C55 a_18020_1244# vss 17.314f
C56 a_20356_13242# a_21648_13242# 0.12734f
C57 a_20356_13242# a_6838_13302# 0.13494f
C58 a_20356_13242# vbn 0.29768f
C59 a_20356_13242# vdd 16.58f
C60 a_20356_13242# vss 0.10663f
C61 a_20356_13242# w_28620_25696# 0.10197f
C62 a_20356_13242# w_6420_25696# 0.01464f
C63 a_2067_26003# a_2135_25448# 0.60941f
C64 a_2067_26003# a_2731_25872# 0.18768f
C65 a_2067_26003# rst_amp 0.52526f
C66 a_2067_26003# vdd 0.49514f
C67 a_2067_26003# vss 0.48709f
C68 a_21038_6704# a_21648_13242# 0.78649f
C69 a_21038_6704# a_28022_1954# 0.13951f
C70 a_21038_6704# a_37038_1140# 0.19124f
C71 a_21038_6704# a_6838_13302# 1.9806f
C72 a_21038_6704# out 0.09438f
C73 a_21038_6704# ref 0.0031301f
C74 a_21038_6704# vbn 19.504f
C75 a_21038_6704# vcm 0.01128f
C76 a_21038_6704# vdd 25.042f
C77 a_21038_6704# vss 12.291f
C78 a_21038_6704# w_28620_25696# 1.029f
C79 a_21038_6704# w_6420_25696# 4.9886f
C80 a_2135_25448# a_2731_25872# 0.44404f
C81 a_2135_25448# a_28022_1954# 3.0782f
C82 a_2135_25448# a_28938_25800# 0.08427f
C83 a_2135_25448# a_36238_23200# 1.3427f
C84 a_2135_25448# a_37038_1140# 4.225f
C85 a_2135_25448# a_40238_24600# 0.49126f
C86 a_2135_25448# a_40316_41200# 0.01304f
C87 a_2135_25448# a_40438_43940# 2.1545f
C88 a_2135_25448# a_5238_25664# 0.47896f
C89 a_2135_25448# a_5338_25800# 0.08427f
C90 a_2135_25448# a_6838_13302# 0.21063f
C91 a_2135_25448# out 0.1509f
C92 a_2135_25448# rec 0.079224f
C93 a_2135_25448# ref 0.078193f
C94 a_2135_25448# rst_amp 0.40535f
C95 a_2135_25448# sw_rec 1.499f
C96 a_2135_25448# sw_rec_b 0.03276f
C97 a_2135_25448# vbn 1.4607f
C98 a_2135_25448# vcm 2.4186f
C99 a_2135_25448# vcmo 0.37737f
C100 a_2135_25448# vdd 3.8867f
C101 a_2135_25448# vg2 0.01059f
C102 a_2135_25448# vrs 0.63632f
C103 a_2135_25448# vss 12.247f
C104 a_2135_25448# w_28620_25696# 0.19748f
C105 a_2135_25448# w_39820_39896# 1.5951f
C106 a_2135_25448# w_5020_25696# 0.90429f
C107 a_2135_25448# w_6420_25696# 1.022f
C108 a_21648_13242# a_6838_13302# 0.13509f
C109 a_21648_13242# vdd 17.857f
C110 a_21648_13242# vss 0.11865f
C111 a_21648_13242# w_28620_25696# 0.09999f
C112 a_2731_25872# a_5238_25664# 1.484f
C113 a_2731_25872# a_5338_25800# 0.01461f
C114 a_2731_25872# a_6838_13302# 0.28426f
C115 a_2731_25872# rec 0.18069f
C116 a_2731_25872# rst_amp 0.13932f
C117 a_2731_25872# sw_rec_b 0.58036f
C118 a_2731_25872# vcm 0.28442f
C119 a_2731_25872# vdd 2.302f
C120 a_2731_25872# vg1 2.0791f
C121 a_2731_25872# vg2 0.63305f
C122 a_2731_25872# vrs 2.4217f
C123 a_2731_25872# vss 3.8804f
C124 a_2731_25872# w_28620_25696# 0.01743f
C125 a_2731_25872# w_5020_25696# 0.48315f
C126 a_2731_25872# w_6420_25696# 1.9958f
C127 a_27748_13242# a_6838_13302# 0.14f
C128 a_27748_13242# out 0.06303f
C129 a_27748_13242# vdd 18.193f
C130 a_27748_13242# vss 0.34755f
C131 a_27748_13242# w_6420_25696# 0.0543f
C132 a_28022_1954# a_36238_23200# 0.07759f
C133 a_28022_1954# a_37038_1140# 1.51f
C134 a_28022_1954# a_40238_24600# 0.33743f
C135 a_28022_1954# a_6838_13302# 2.6611f
C136 a_28022_1954# out 0.8443f
C137 a_28022_1954# ref 1.0952f
C138 a_28022_1954# sw_rec 0.74962f
C139 a_28022_1954# vbn 0.66131f
C140 a_28022_1954# vcmo 0.10405f
C141 a_28022_1954# vdd 4.0153f
C142 a_28022_1954# vss 24.856f
C143 a_28022_1954# w_39820_39896# 0.85711f
C144 a_28022_1954# w_6420_25696# 0.31009f
C145 a_28938_25800# a_5238_25664# 1.2235f
C146 a_28938_25800# out 0.10445f
C147 a_28938_25800# sw_rec 0.01103f
C148 a_28938_25800# vcm 0.18507f
C149 a_28938_25800# vss 0.72293f
C150 a_28938_25800# w_28620_25696# 0.12806f
C151 a_36238_23200# a_37038_1140# 0.19288f
C152 a_36238_23200# a_40238_24600# 0.06076f
C153 a_36238_23200# out 0.21309f
C154 a_36238_23200# sw_rec 0.20946f
C155 a_36238_23200# vbn 0.17015f
C156 a_36238_23200# vcmo 1.5552f
C157 a_36238_23200# vdd 0.01914f
C158 a_36238_23200# vss 4.3952f
C159 a_36238_23200# w_39820_39896# 0.29745f
C160 a_36238_23200# w_6420_25696# 0.09973f
C161 a_37038_1140# a_40238_24600# 0.09741f
C162 a_37038_1140# a_6838_13302# 2.5311f
C163 a_37038_1140# out 0.16645f
C164 a_37038_1140# sw_rec 0.15934f
C165 a_37038_1140# vbn 0.82337f
C166 a_37038_1140# vcmo 0.86588f
C167 a_37038_1140# vdd 14.719f
C168 a_37038_1140# vss 7.8221f
C169 a_37038_1140# w_39820_39896# 0.4022f
C170 a_37038_1140# w_6420_25696# 0.66806f
C171 a_40138_40000# out 0.24018f
C172 a_40138_40000# vss 0.87592f
C173 a_40138_40000# w_39820_39896# 0.25957f
C174 a_40138_40000# w_6420_25696# 0.057467f
C175 a_40238_24600# a_40316_41200# 0.54084f
C176 a_40238_24600# a_40438_43940# 1.149f
C177 a_40238_24600# out 4.964f
C178 a_40238_24600# ref 1.5522f
C179 a_40238_24600# sw_rec 2.818f
C180 a_40238_24600# vbn 0.07347f
C181 a_40238_24600# vcmo 0.21572f
C182 a_40238_24600# vdd 9.0601f
C183 a_40238_24600# vss 12.11f
C184 a_40238_24600# w_39820_39896# 0.38857f
C185 a_40316_41200# a_40438_43940# 0.73451f
C186 a_40316_41200# sw_rec 0.6894f
C187 a_40316_41200# vss 0.97514f
C188 a_40438_43940# sw_rec 1.2258f
C189 a_40438_43940# vdd 2.9928f
C190 a_40438_43940# vss 2.2707f
C191 a_5238_25664# a_5338_25800# 1.3045f
C192 a_5238_25664# a_6838_13302# 1.8526f
C193 a_5238_25664# out 0.21632f
C194 a_5238_25664# rec 0.66865f
C195 a_5238_25664# ref 0.00058442f
C196 a_5238_25664# sw_rec 1.8154f
C197 a_5238_25664# sw_rec_b 0.07931f
C198 a_5238_25664# vbn 0.66584f
C199 a_5238_25664# vcm 1.0779f
C200 a_5238_25664# vdd 4.0399f
C201 a_5238_25664# vg1 0.18648f
C202 a_5238_25664# vg2 0.11179f
C203 a_5238_25664# vrs 0.43038f
C204 a_5238_25664# vss 7.466f
C205 a_5238_25664# w_28620_25696# 0.81841f
C206 a_5238_25664# w_5020_25696# 0.64494f
C207 a_5238_25664# w_6420_25696# 1.9455f
C208 a_5338_25800# rec 0.00024764f
C209 a_5338_25800# vdd 0.02186f
C210 a_5338_25800# vss 0.69874f
C211 a_5338_25800# w_5020_25696# 0.15338f
C212 a_5338_25800# w_6420_25696# 0.26399f
C213 a_6838_13302# out 0.59853f
C214 a_6838_13302# vbn 0.61236f
C215 a_6838_13302# vdd 5.1721f
C216 a_6838_13302# vrs 0.02077f
C217 a_6838_13302# vss 44.877f
C218 a_6838_13302# w_28620_25696# 30.737f
C219 a_6838_13302# w_5020_25696# 2.1864f
C220 a_6838_13302# w_6420_25696# 20.154f
C221 a_856_1244# vss 18.482f
C222 out sw_rec 5.2886f
C223 out vbn 5.2448f
C224 out vcm 0.16795f
C225 out vcmo 0.26546f
C226 out vdd 2.882f
C227 out vss 24.007f
C228 out w_28620_25696# 0.06552f
C229 out w_39820_39896# 2.1143f
C230 out w_6420_25696# 0.89307f
C231 rec ref 7.0348f
C232 rec rst_amp 0.027239f
C233 rec sw_rec 1.4776f
C234 rec sw_rec_b 1.228f
C235 rec vbn 0.25089f
C236 rec vcm 1.2283f
C237 rec vcmo 1.0714f
C238 rec vdd 0.83049f
C239 rec vg1 0.51411f
C240 rec vg2 1.8666f
C241 rec vrs 0.12584f
C242 rec vss 70.739f
C243 rec w_28620_25696# 2.3478f
C244 rec w_5020_25696# 9.2948f
C245 rec w_6420_25696# 0.0023674f
C246 ref rst_amp 0.26865f
C247 ref sw_rec 1.2958f
C248 ref sw_rec_b 0.48463f
C249 ref vbn 1.4982f
C250 ref vcm 1.0178f
C251 ref vcmo 1.2393f
C252 ref vdd 0.28203f
C253 ref vg1 0.45416f
C254 ref vg2 1.6173f
C255 ref vrs 0.44618f
C256 ref vss 78.893f
C257 ref w_28620_25696# 18.07f
C258 ref w_39820_39896# 0.92549f
C259 ref w_5020_25696# 0.2674f
C260 ref w_6420_25696# 0.17058f
C261 rst_amp sw_rec_b 7.9198f
C262 rst_amp vcm 7.1875e-06f
C263 rst_amp vdd 0.48739f
C264 rst_amp vg1 0.66689f
C265 rst_amp vg2 0.04896f
C266 rst_amp vrs 0.10611f
C267 rst_amp vss 5.1175f
C268 rst_amp w_28620_25696# 0.02012f
C269 rst_amp w_5020_25696# 0.06392f
C270 rst_amp w_6420_25696# 1.2294e-06f
C271 sw_rec vbn 0.68629f
C272 sw_rec vcm 12.193f
C273 sw_rec vcmo 0.18238f
C274 sw_rec vdd 3.8376f
C275 sw_rec vg1 0.25854f
C276 sw_rec vg2 0.06961f
C277 sw_rec vrs 0.0561f
C278 sw_rec vss 21.895f
C279 sw_rec w_28620_25696# 1.2339f
C280 sw_rec w_39820_39896# 0.30563f
C281 sw_rec w_5020_25696# 0.01323f
C282 sw_rec w_6420_25696# 0.1634f
C283 sw_rec_b vcm 0.55371f
C284 sw_rec_b vdd 0.04335f
C285 sw_rec_b vg1 11.143f
C286 sw_rec_b vg2 2.5311f
C287 sw_rec_b vrs 0.27611f
C288 sw_rec_b vss 5.1286f
C289 sw_rec_b w_28620_25696# 0.03218f
C290 sw_rec_b w_5020_25696# 0.77965f
C291 sw_rec_b w_6420_25696# 0.1054f
C292 vbn vcm 21.523f
C293 vbn vcmo 9.8839f
C294 vbn vdd 3.7763f
C295 vbn vg1 0.05125f
C296 vbn vg2 0.05837f
C297 vbn vrs 0.20544f
C298 vbn vss 89.515f
C299 vbn w_28620_25696# 1.4593f
C300 vbn w_5020_25696# 1.4597f
C301 vbn w_6420_25696# 4.3267f
C302 vcm vcmo 0.1411f
C303 vcm vdd 2.5652f
C304 vcm vg1 0.63278f
C305 vcm vg2 0.3837f
C306 vcm vrs 0.04692f
C307 vcm vss 10.445f
C308 vcm w_28620_25696# 2.8161f
C309 vcm w_39820_39896# 0.01133f
C310 vcm w_6420_25696# 0.019692f
C311 vcmo vdd 0.55843f
C312 vcmo vg1 0.03924f
C313 vcmo vg2 0.07295f
C314 vcmo vrs 0.24327f
C315 vcmo vss 40.242f
C316 vcmo w_28620_25696# 1.0017f
C317 vcmo w_39820_39896# 2.5873f
C318 vcmo w_5020_25696# 0.01903f
C319 vcmo w_6420_25696# 1.3019f
C320 vdd vg1 0.60245f
C321 vdd vg2 0.99531f
C322 vdd vrs 1.0416f
C323 vdd vss 1184.2f
C324 vdd w_28620_25696# 12.043f
C325 vdd w_39820_39896# 0.07243f
C326 vdd w_5020_25696# 13.026f
C327 vdd w_6420_25696# 5.1122f
C328 vg1 vg2 2.8659f
C329 vg1 vrs 9.6978f
C330 vg1 vss 4.4747f
C331 vg1 w_28620_25696# 0.09994f
C332 vg1 w_5020_25696# 0.48572f
C333 vg1 w_6420_25696# 0.1192f
C334 vg2 vrs 9.8022f
C335 vg2 vss 8.2484f
C336 vg2 w_28620_25696# 0.22678f
C337 vg2 w_5020_25696# 0.57891f
C338 vg2 w_6420_25696# 0.0059727f
C339 vrs vss 4.5746f
C340 vrs w_28620_25696# 0.15289f
C341 vrs w_5020_25696# 0.669f
C342 vrs w_6420_25696# 1.2937f
C343 vss w_28620_25696# 14.775f
C344 vss w_39820_39896# 32.525f
C345 vss w_5020_25696# 11.145f
C346 vss w_6420_25696# 37.03f
C347 w_28620_25696# w_5020_25696# 13.479f
C348 w_28620_25696# w_6420_25696# 0.3033f
C349 w_39820_39896# w_6420_25696# 2.4764f
C350 w_5020_25696# w_6420_25696# 1.8946f
* L2b (flow.py bleed_floating): capacitor-only nodes (dummy poly) get 1 Tohm to ground, otherwise the DC operating point is singular
Rfloat_0 a_1048_13242# 0 1e12
Rfloat_1 a_18020_1244# 0 1e12
Rfloat_2 a_20356_13242# 0 1e12
Rfloat_3 a_21648_13242# 0 1e12
Rfloat_4 a_27748_13242# 0 1e12
Rfloat_5 a_856_1244# 0 1e12
.ends
