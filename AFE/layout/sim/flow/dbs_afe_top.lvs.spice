* NGSPICE file created from dbs_afe_top.ext - technology: gf180mcuD

.subckt cap_nmos a_88_n92# a_0_0#
X0 a_88_n92# a_0_0# cap_nmos_03v3 c_width=20u c_length=20u
.ends

.subckt pfet__15 w_n180_n88# a_38_n60# a_n92_0# a_138_0#
X0 a_138_0# a_38_n60# a_n92_0# w_n180_n88# pfet_03v3 ad=0.65p pd=3.3u as=0.65p ps=3.3u w=1u l=0.5u
.ends

.subckt pfet__14 w_n180_n88# a_38_n60# a_n92_0# a_138_0#
X0 a_138_0# a_38_n60# a_n92_0# w_n180_n88# pfet_03v3 ad=1.3p pd=5.3u as=1.3p ps=5.3u w=2u l=0.5u
.ends

.subckt sp_os m1_n250_4950# m1_n250_1950# m1_n50_750# m1_184_2935# m1_184_4536# m1_184_1535#
+ m1_184_135# m1_n250_550# w_n860_n660# m1_n50_5150# m1_n250_3350# m1_n50_3550# m1_n50_2150#
Xpfet__15_1 w_n860_n660# m1_n50_2150# m1_n250_1950# m1_184_1535# pfet__15
Xpfet__15_0 w_n860_n660# m1_n50_3550# m1_n250_3350# m1_184_2935# pfet__15
Xpfet__15_2 w_n860_n660# m1_n50_750# m1_n250_550# m1_184_135# pfet__15
Xpfet__14_0 w_n860_n660# m1_n50_5150# m1_n250_4950# m1_184_4536# pfet__14
.ends

.subckt cap_mim__19 m4_n120_n120# m4_0_0#
X0 m4_0_0# m4_n120_n120# cap_mim_2f0_m4m5_noshield c_width=38.59u c_length=38.59u
.ends

.subckt cin2 m4_8200_7200# m4_7698_280#
Xcap_mim__19_0 m4_7698_280# m4_8200_7200# cap_mim__19
.ends

.subckt nfet__4 a_15302_0# a_13598_n60# a_3550_0# a_838_0# a_17214_n60# a_10886_n60#
+ a_9878_0# a_14502_n60# a_20726_0# a_8174_n60# a_5462_n60# a_2750_n60# a_21630_0#
+ a_18918_0# a_7166_0# a_8070_0# a_19822_0# a_13494_0# a_20830_n60# a_19022_n60# a_12694_n60#
+ a_16206_0# a_16310_n60# a_9982_n60# a_4454_0# a_17110_0# a_7270_n60# a_10782_0#
+ a_38_n60# a_4558_n60# a_1742_0# a_n84_0# a_1846_n60# a_11790_n60# a_14398_0# a_8974_0#
+ a_18118_n60# a_15406_n60# a_5358_0# a_9078_n60# a_18014_0# a_6366_n60# a_6262_0#
+ a_11686_0# a_3654_n60# a_12590_0# a_2646_0# a_19926_n60# a_942_n60# VSUBS
X0 a_8070_0# a_7270_n60# a_7166_0# VSUBS nfet_03v3 ad=4.16p pd=16.52u as=4.16p ps=16.52u w=16u l=4u
X1 a_17110_0# a_16310_n60# a_16206_0# VSUBS nfet_03v3 ad=4.16p pd=16.52u as=4.16p ps=16.52u w=16u l=4u
X2 a_13494_0# a_12694_n60# a_12590_0# VSUBS nfet_03v3 ad=4.16p pd=16.52u as=4.16p ps=16.52u w=16u l=4u
X3 a_19822_0# a_19022_n60# a_18918_0# VSUBS nfet_03v3 ad=4.16p pd=16.52u as=4.16p ps=16.52u w=16u l=4u
X4 a_21630_0# a_20830_n60# a_20726_0# VSUBS nfet_03v3 ad=9.76p pd=33.22u as=4.16p ps=16.52u w=16u l=4u
X5 a_10782_0# a_9982_n60# a_9878_0# VSUBS nfet_03v3 ad=4.16p pd=16.52u as=4.16p ps=16.52u w=16u l=4u
X6 a_3550_0# a_2750_n60# a_2646_0# VSUBS nfet_03v3 ad=4.16p pd=16.52u as=4.16p ps=16.52u w=16u l=4u
X7 a_15302_0# a_14502_n60# a_14398_0# VSUBS nfet_03v3 ad=4.16p pd=16.52u as=4.16p ps=16.52u w=16u l=4u
X8 a_6262_0# a_5462_n60# a_5358_0# VSUBS nfet_03v3 ad=4.16p pd=16.52u as=4.16p ps=16.52u w=16u l=4u
X9 a_11686_0# a_10886_n60# a_10782_0# VSUBS nfet_03v3 ad=4.16p pd=16.52u as=4.16p ps=16.52u w=16u l=4u
X10 a_8974_0# a_8174_n60# a_8070_0# VSUBS nfet_03v3 ad=4.16p pd=16.52u as=4.16p ps=16.52u w=16u l=4u
X11 a_18014_0# a_17214_n60# a_17110_0# VSUBS nfet_03v3 ad=4.16p pd=16.52u as=4.16p ps=16.52u w=16u l=4u
X12 a_14398_0# a_13598_n60# a_13494_0# VSUBS nfet_03v3 ad=4.16p pd=16.52u as=4.16p ps=16.52u w=16u l=4u
X13 a_20726_0# a_19926_n60# a_19822_0# VSUBS nfet_03v3 ad=4.16p pd=16.52u as=4.16p ps=16.52u w=16u l=4u
X14 a_4454_0# a_3654_n60# a_3550_0# VSUBS nfet_03v3 ad=4.16p pd=16.52u as=4.16p ps=16.52u w=16u l=4u
X15 a_7166_0# a_6366_n60# a_6262_0# VSUBS nfet_03v3 ad=4.16p pd=16.52u as=4.16p ps=16.52u w=16u l=4u
X16 a_16206_0# a_15406_n60# a_15302_0# VSUBS nfet_03v3 ad=4.16p pd=16.52u as=4.16p ps=16.52u w=16u l=4u
X17 a_18918_0# a_18118_n60# a_18014_0# VSUBS nfet_03v3 ad=4.16p pd=16.52u as=4.16p ps=16.52u w=16u l=4u
X18 a_9878_0# a_9078_n60# a_8974_0# VSUBS nfet_03v3 ad=4.16p pd=16.52u as=4.16p ps=16.52u w=16u l=4u
X19 a_12590_0# a_11790_n60# a_11686_0# VSUBS nfet_03v3 ad=4.16p pd=16.52u as=4.16p ps=16.52u w=16u l=4u
X20 a_1742_0# a_942_n60# a_838_0# VSUBS nfet_03v3 ad=4.16p pd=16.52u as=4.16p ps=16.52u w=16u l=4u
X21 a_838_0# a_38_n60# a_n84_0# VSUBS nfet_03v3 ad=4.16p pd=16.52u as=9.76p ps=33.22u w=16u l=4u
X22 a_2646_0# a_1846_n60# a_1742_0# VSUBS nfet_03v3 ad=4.16p pd=16.52u as=4.16p ps=16.52u w=16u l=4u
X23 a_5358_0# a_4558_n60# a_4454_0# VSUBS nfet_03v3 ad=4.16p pd=16.52u as=4.16p ps=16.52u w=16u l=4u
.ends

.subckt sink1 m1_n80_n496# m1_n500_3100# nfet__4_0/VSUBS m1_840_2932#
Xnfet__4_0 m1_840_2932# m1_n500_3100# m1_n80_n496# m1_840_2932# m1_n500_3100# m1_n500_3100#
+ m1_840_2932# m1_n500_3100# m1_840_2932# m1_n500_3100# m1_n500_3100# m1_n500_3100#
+ m1_n80_n496# m1_840_2932# m1_n80_n496# m1_840_2932# m1_n80_n496# m1_840_2932# m1_n500_3100#
+ m1_n500_3100# m1_n500_3100# m1_n80_n496# m1_n500_3100# m1_n500_3100# m1_840_2932#
+ m1_840_2932# m1_n500_3100# m1_n80_n496# m1_n500_3100# m1_n500_3100# m1_n80_n496#
+ m1_n80_n496# m1_n500_3100# m1_n500_3100# m1_n80_n496# m1_n80_n496# m1_n500_3100#
+ m1_n500_3100# m1_n80_n496# m1_n500_3100# m1_n80_n496# m1_n500_3100# m1_840_2932#
+ m1_840_2932# m1_n500_3100# m1_n80_n496# m1_840_2932# m1_n500_3100# m1_n500_3100#
+ nfet__4_0/VSUBS nfet__4
.ends

.subckt gf180mcu_fd_sc_mcu7t5v0__or2_1 w_n86_352# a_359_48# a_47_93# a_135_48# a_731_472#
+ a_459_603# VSUBS
X0 a_255_603# a_135_48# a_67_603# w_n86_352# pfet_05v0 ad=0.1469p pd=1.085u as=0.2486p ps=2.01u w=0.565u l=0.5u
X1 a_731_472# a_67_603# a_47_93# VSUBS nfet_05v0 ad=0.3608p pd=2.52u as=0.2288p ps=1.58u w=0.82u l=0.6u
X2 a_459_603# a_359_48# a_255_603# w_n86_352# pfet_05v0 ad=0.38705p pd=2.08u as=0.1469p ps=1.085u w=0.565u l=0.5u
X3 a_47_93# a_359_48# a_67_603# VSUBS nfet_05v0 ad=0.2288p pd=1.58u as=93.59999f ps=0.88u w=0.36u l=0.6u
X4 a_731_472# a_67_603# a_459_603# w_n86_352# pfet_05v0 ad=0.5368p pd=3.32u as=0.38705p ps=2.08u w=1.22u l=0.5u
X5 a_67_603# a_135_48# a_47_93# VSUBS nfet_05v0 ad=93.59999f pd=0.88u as=0.1584p ps=1.6u w=0.36u l=0.6u
.ends

.subckt or2 m1_950_780# m1_148_294# m1_366_474# m1_734_534# VSUBS
Xgf180mcu_fd_sc_mcu7t5v0__or2_1_0 m1_950_780# m1_366_474# VSUBS m1_148_294# m1_734_534#
+ m1_950_780# VSUBS gf180mcu_fd_sc_mcu7t5v0__or2_1
.ends

.subckt cap_mim__22 m4_n120_n120# m4_0_0#
X0 m4_0_0# m4_n120_n120# cap_mim_2f0_m4m5_noshield c_width=44.595u c_length=44.595u
.ends

.subckt ct m4_9400_8400# m4_8899_280#
Xcap_mim__22_0 m4_8899_280# m4_9400_8400# cap_mim__22
.ends

.subckt cap_mim__23 m4_n120_n120# m4_0_0#
X0 m4_0_0# m4_n120_n120# cap_mim_2f0_m4m5_noshield c_width=61.15u c_length=61.15u
.ends

.subckt cin_blk m5_6100_25300# m4_6000_n1400# m4_12330_6900# m4_n1200_18000#
Xcap_mim__23_0 m4_12330_6900# m4_6000_n1400# cap_mim__23
Xcap_mim__23_1 m4_n1200_18000# m5_6100_25300# cap_mim__23
Xcap_mim__23_2 m4_n1200_18000# m5_6100_25300# cap_mim__23
Xcap_mim__23_3 m4_12330_6900# m4_6000_n1400# cap_mim__23
.ends

.subckt cap_mim__17 m4_n120_n120# m4_0_0#
X0 m4_0_0# m4_n120_n120# cap_mim_2f0_m4m5_noshield c_width=22u c_length=22u
.ends

.subckt cc1 m4_4380_280# m4_5000_3800#
Xcap_mim__17_0 m4_4380_280# m4_5000_3800# cap_mim__17
.ends

.subckt pfet__16 w_n180_n104# a_n92_n16# a_138_0# a_38_n136#
X0 a_138_0# a_38_n136# a_n92_n16# w_n180_n104# pfet_03v3 ad=0.2166p pd=2.06u as=0.2166p ps=2.06u w=0.22u l=0.5u
.ends

.subckt pr3 m1_184_n450# m1_n50_n450# w_n20_n104# w_1380_n104# m1_1350_n450# m1_1584_n450#
Xpfet__16_0 w_1380_n104# w_1380_n104# m1_1584_n450# m1_1350_n450# pfet__16
Xpfet__16_1 w_n20_n104# w_n20_n104# m1_184_n450# m1_n50_n450# pfet__16
.ends

.subckt cap_mim__18 m4_n120_n120# m4_0_0#
X0 m4_0_0# m4_n120_n120# cap_mim_2f0_m4m5_noshield c_width=8.45u c_length=8.45u
.ends

.subckt cf1 m4_1670_280# m4_2200_1000#
Xcap_mim__18_0 m4_1670_280# m4_2200_1000# cap_mim__18
.ends

.subckt nfet__5 a_3550_0# a_838_0# a_2750_n60# a_4454_0# a_38_n60# a_4558_n60# a_1742_0#
+ a_n84_0# a_1846_n60# a_5358_0# a_3654_n60# a_2646_0# a_942_n60# VSUBS
X0 a_3550_0# a_2750_n60# a_2646_0# VSUBS nfet_03v3 ad=4.16p pd=16.52u as=4.16p ps=16.52u w=16u l=4u
X1 a_4454_0# a_3654_n60# a_3550_0# VSUBS nfet_03v3 ad=4.16p pd=16.52u as=4.16p ps=16.52u w=16u l=4u
X2 a_1742_0# a_942_n60# a_838_0# VSUBS nfet_03v3 ad=4.16p pd=16.52u as=4.16p ps=16.52u w=16u l=4u
X3 a_838_0# a_38_n60# a_n84_0# VSUBS nfet_03v3 ad=4.16p pd=16.52u as=9.76p ps=33.22u w=16u l=4u
X4 a_2646_0# a_1846_n60# a_1742_0# VSUBS nfet_03v3 ad=4.16p pd=16.52u as=4.16p ps=16.52u w=16u l=4u
X5 a_5358_0# a_4558_n60# a_4454_0# VSUBS nfet_03v3 ad=9.76p pd=33.22u as=4.16p ps=16.52u w=16u l=4u
.ends

.subckt xms m1_n80_n496# m1_n500_3100# nfet__5_0/VSUBS m1_840_2932#
Xnfet__5_0 m1_n80_n496# m1_840_2932# m1_n500_3100# m1_840_2932# m1_n500_3100# m1_n500_3100#
+ m1_n80_n496# m1_n80_n496# m1_n500_3100# m1_n80_n496# m1_n500_3100# m1_840_2932#
+ m1_n500_3100# nfet__5_0/VSUBS nfet__5
.ends

.subckt pfet__13 w_n180_n88# a_38_n60# a_n92_0# a_138_0#
X0 a_138_0# a_38_n60# a_n92_0# w_n180_n88# pfet_03v3 ad=0.325p pd=2.3u as=0.325p ps=2.3u w=0.5u l=0.5u
.ends

.subckt sp_a m1_2984_336# m1_n250_350# m1_1584_85# w_n860_n660# m1_1350_550# m1_1150_350#
+ m1_184_85# m1_n50_550# m1_2750_950# m1_2550_750#
Xpfet__13_0 w_n860_n660# m1_1350_550# m1_1150_350# m1_1584_85# pfet__13
Xpfet__13_1 w_n860_n660# m1_n50_550# m1_n250_350# m1_184_85# pfet__13
Xpfet__14_0 w_n860_n660# m1_2750_950# m1_2550_750# m1_2984_336# pfet__14
.ends

.subckt nfet_06v0_nvt__10 a_422_0# a_n92_0# a_22_n46# VSUBS
X0 a_422_0# a_22_n46# a_n92_0# VSUBS nfet_06v0_nvt ad=5.7p pd=21.14u as=5.7p ps=21.14u w=10u l=2u
.ends

.subckt fol m1_452_1952# m1_150_2118# m1_n250_2350# nfet_06v0_nvt__10_0/VSUBS
Xnfet_06v0_nvt__10_0 m1_452_1952# m1_n250_2350# m1_150_2118# nfet_06v0_nvt__10_0/VSUBS
+ nfet_06v0_nvt__10
.ends

.subckt pr1 m1_184_n450# m1_n50_n450# w_n20_n104# w_1380_n104# m1_1350_n450# m1_1584_n450#
Xpfet__16_0 w_1380_n104# w_1380_n104# m1_1584_n450# m1_1350_n450# pfet__16
Xpfet__16_1 w_n20_n104# w_n20_n104# m1_184_n450# m1_n50_n450# pfet__16
.ends

.subckt pfet__9 a_4038_0# w_n180_n88# a_38_n60# a_n92_0#
X0 a_4038_0# a_38_n60# a_n92_0# w_n180_n88# pfet_03v3 ad=0.65p pd=3.3u as=0.65p ps=3.3u w=1u l=20u
.ends

.subckt s2p m1_n250_1950# m1_4084_1535# m1_150_332# m1_n250_550# w_n860_n660# m1_4084_135#
+ m1_150_1732#
Xpfet__9_0 m1_4084_1535# w_n860_n660# m1_150_1732# m1_n250_1950# pfet__9
Xpfet__9_1 m1_4084_135# w_n860_n660# m1_150_332# m1_n250_550# pfet__9
.ends

.subckt pfet__0 a_1046_n60# a_2558_n60# a_1950_0# a_1446_0# a_1550_n60# a_2454_0#
+ a_3062_n60# a_3462_0# w_n180_n88# a_38_n60# a_2958_0# a_3966_0# a_n92_0# a_942_0#
+ a_3566_n60# a_2054_n60# a_542_n60# a_438_0#
X0 a_942_0# a_542_n60# a_438_0# w_n180_n88# pfet_03v3 ad=13p pd=50.52u as=13p ps=50.52u w=50u l=2u
X1 a_3462_0# a_3062_n60# a_2958_0# w_n180_n88# pfet_03v3 ad=13p pd=50.52u as=13p ps=50.52u w=50u l=2u
X2 a_1950_0# a_1550_n60# a_1446_0# w_n180_n88# pfet_03v3 ad=13p pd=50.52u as=13p ps=50.52u w=50u l=2u
X3 a_1446_0# a_1046_n60# a_942_0# w_n180_n88# pfet_03v3 ad=13p pd=50.52u as=13p ps=50.52u w=50u l=2u
X4 a_2958_0# a_2558_n60# a_2454_0# w_n180_n88# pfet_03v3 ad=13p pd=50.52u as=13p ps=50.52u w=50u l=2u
X5 a_3966_0# a_3566_n60# a_3462_0# w_n180_n88# pfet_03v3 ad=32.5p pd=0.1013m as=13p ps=50.52u w=50u l=2u
X6 a_2454_0# a_2054_n60# a_1950_0# w_n180_n88# pfet_03v3 ad=13p pd=50.52u as=13p ps=50.52u w=50u l=2u
X7 a_438_0# a_38_n60# a_n92_0# w_n180_n88# pfet_03v3 ad=13p pd=50.52u as=32.5p ps=0.1013m w=50u l=2u
.ends

.subckt pair_a2 m1_n84_n498# pfet__0_0/w_n180_n88# m1_n500_9900# m1_440_9747#
Xpfet__0_0 m1_n500_9900# m1_n500_9900# m1_n84_n498# m1_440_9747# m1_n500_9900# m1_440_9747#
+ m1_n500_9900# m1_440_9747# pfet__0_0/w_n180_n88# m1_n500_9900# m1_n84_n498# m1_n84_n498#
+ m1_n84_n498# m1_n84_n498# m1_n500_9900# m1_n500_9900# m1_n500_9900# m1_440_9747#
+ pfet__0
.ends

.subckt pair_b2 m1_n84_n498# pfet__0_0/w_n180_n88# m1_n500_9900# m1_440_9747#
Xpfet__0_0 m1_n500_9900# m1_n500_9900# m1_n84_n498# m1_440_9747# m1_n500_9900# m1_440_9747#
+ m1_n500_9900# m1_440_9747# pfet__0_0/w_n180_n88# m1_n500_9900# m1_n84_n498# m1_n84_n498#
+ m1_n84_n498# m1_n84_n498# m1_n500_9900# m1_n500_9900# m1_n500_9900# m1_440_9747#
+ pfet__0
.ends

.subckt pair_a1 m1_n84_n498# pfet__0_0/w_n180_n88# m1_n500_9900# m1_440_9747#
Xpfet__0_0 m1_n500_9900# m1_n500_9900# m1_n84_n498# m1_440_9747# m1_n500_9900# m1_440_9747#
+ m1_n500_9900# m1_440_9747# pfet__0_0/w_n180_n88# m1_n500_9900# m1_n84_n498# m1_n84_n498#
+ m1_n84_n498# m1_n84_n498# m1_n500_9900# m1_n500_9900# m1_n500_9900# m1_440_9747#
+ pfet__0
.ends

.subckt pfet__1 a_3550_0# a_838_0# a_2750_n60# w_n180_n88# a_4454_0# a_38_n60# a_4558_n60#
+ a_n92_0# a_1742_0# a_1846_n60# a_5358_0# a_3654_n60# a_2646_0# a_942_n60#
X0 a_3550_0# a_2750_n60# a_2646_0# w_n180_n88# pfet_03v3 ad=13p pd=50.52u as=13p ps=50.52u w=50u l=4u
X1 a_4454_0# a_3654_n60# a_3550_0# w_n180_n88# pfet_03v3 ad=13p pd=50.52u as=13p ps=50.52u w=50u l=4u
X2 a_1742_0# a_942_n60# a_838_0# w_n180_n88# pfet_03v3 ad=13p pd=50.52u as=13p ps=50.52u w=50u l=4u
X3 a_838_0# a_38_n60# a_n92_0# w_n180_n88# pfet_03v3 ad=13p pd=50.52u as=32.5p ps=0.1013m w=50u l=4u
X4 a_2646_0# a_1846_n60# a_1742_0# w_n180_n88# pfet_03v3 ad=13p pd=50.52u as=13p ps=50.52u w=50u l=4u
X5 a_5358_0# a_4558_n60# a_4454_0# w_n180_n88# pfet_03v3 ad=32.5p pd=0.1013m as=13p ps=50.52u w=50u l=4u
.ends

.subckt tail6 m1_n84_n498# m1_4456_9747# m1_2648_9747# m1_n500_9900# pfet__1_0/w_n180_n88#
+ m1_840_9747#
Xpfet__1_0 m1_n84_n498# m1_840_9747# m1_n500_9900# pfet__1_0/w_n180_n88# m1_4456_9747#
+ m1_n500_9900# m1_n500_9900# m1_n84_n498# m1_n84_n498# m1_n500_9900# m1_n84_n498#
+ m1_n500_9900# m1_2648_9747# m1_n500_9900# pfet__1
.ends

.subckt pair_b1 m1_n84_n498# pfet__0_0/w_n180_n88# m1_n500_9900# m1_440_9747#
Xpfet__0_0 m1_n500_9900# m1_n500_9900# m1_n84_n498# m1_440_9747# m1_n500_9900# m1_440_9747#
+ m1_n500_9900# m1_440_9747# pfet__0_0/w_n180_n88# m1_n500_9900# m1_n84_n498# m1_n84_n498#
+ m1_n84_n498# m1_n84_n498# m1_n500_9900# m1_n500_9900# m1_n500_9900# m1_440_9747#
+ pfet__0
.ends

.subckt ota_p tail6_0/m1_n500_9900# pair_a2_0/m1_n84_n498# pair_b1_0/m1_n500_9900#
+ w_n660_n1060# pair_b1_0/m1_440_9747# tail6_0/m1_840_9747# pair_a2_0/m1_n500_9900#
+ pair_a1_0/m1_440_9747# pair_a1_0/m1_n500_9900# pair_b2_0/m1_440_9747# pair_b1_0/m1_n84_n498#
+ tail6_0/m1_n84_n498# pair_a2_0/m1_440_9747# pair_a1_0/m1_n84_n498# tail6_0/m1_4456_9747#
+ pair_b2_0/m1_n84_n498# pair_b2_0/m1_n500_9900# tail6_0/m1_2648_9747#
Xpair_a2_0 pair_a2_0/m1_n84_n498# w_n660_n1060# pair_a2_0/m1_n500_9900# pair_a2_0/m1_440_9747#
+ pair_a2
Xpair_b2_0 pair_b2_0/m1_n84_n498# w_n660_n1060# pair_b2_0/m1_n500_9900# pair_b2_0/m1_440_9747#
+ pair_b2
Xpair_a1_0 pair_a1_0/m1_n84_n498# w_n660_n1060# pair_a1_0/m1_n500_9900# pair_a1_0/m1_440_9747#
+ pair_a1
Xtail6_0 tail6_0/m1_n84_n498# tail6_0/m1_4456_9747# tail6_0/m1_2648_9747# tail6_0/m1_n500_9900#
+ w_n660_n1060# tail6_0/m1_840_9747# tail6
Xpair_b1_0 pair_b1_0/m1_n84_n498# w_n660_n1060# pair_b1_0/m1_n500_9900# pair_b1_0/m1_440_9747#
+ pair_b1
.ends

.subckt nfet__3 a_6542_0# a_6646_n60# a_38_n60# a_13150_0# a_n84_0# a_9950_n60# a_3342_n60#
+ a_3238_0# a_9846_0# VSUBS
X0 a_9846_0# a_6646_n60# a_6542_0# VSUBS nfet_03v3 ad=13p pd=50.52u as=13p ps=50.52u w=50u l=16u
X1 a_6542_0# a_3342_n60# a_3238_0# VSUBS nfet_03v3 ad=13p pd=50.52u as=13p ps=50.52u w=50u l=16u
X2 a_13150_0# a_9950_n60# a_9846_0# VSUBS nfet_03v3 ad=30.5p pd=0.10122m as=13p ps=50.52u w=50u l=16u
X3 a_3238_0# a_38_n60# a_n84_0# VSUBS nfet_03v3 ad=13p pd=50.52u as=30.5p ps=0.10122m w=50u l=16u
.ends

.subckt xm6 m1_n80_n496# nfet__3_0/VSUBS m1_3240_9749# m1_n500_9900#
Xnfet__3_0 m1_n80_n496# m1_n500_9900# m1_n500_9900# m1_n80_n496# m1_n80_n496# m1_n500_9900#
+ m1_n500_9900# m1_3240_9749# m1_3240_9749# nfet__3_0/VSUBS nfet__3
.ends

.subckt cf1p m4_1670_280# m4_2200_1000#
Xcap_mim__18_0 m4_1670_280# m4_2200_1000# cap_mim__18
.ends

.subckt nfet__12 a_38_n60# a_n84_0# a_138_0# VSUBS
X0 a_138_0# a_38_n60# a_n84_0# VSUBS nfet_03v3 ad=0.61p pd=3.22u as=0.61p ps=3.22u w=1u l=0.5u
.ends

.subckt sn_os m1_180_2935# m1_180_1535# m1_n250_1950# m1_n50_750# m1_180_135# nfet__12_2/VSUBS
+ m1_n250_550# m1_n250_3350# m1_n50_3550# m1_n50_2150#
Xnfet__12_0 m1_n50_3550# m1_n250_3350# m1_180_2935# nfet__12_2/VSUBS nfet__12
Xnfet__12_1 m1_n50_2150# m1_n250_1950# m1_180_1535# nfet__12_2/VSUBS nfet__12
Xnfet__12_2 m1_n50_750# m1_n250_550# m1_180_135# nfet__12_2/VSUBS nfet__12
.ends

.subckt cap_mim__20 m4_n120_n120# m4_0_0#
X0 m4_0_0# m4_n120_n120# cap_mim_2f0_m4m5_noshield c_width=31.465u c_length=31.465u
.ends

.subckt cc2 m4_6273_280# m4_6800_5600#
Xcap_mim__20_0 m4_6273_280# m4_6800_5600# cap_mim__20
.ends

.subckt cap_mim__21 m4_n120_n120# m4_0_0#
X0 m4_0_0# m4_n120_n120# cap_mim_2f0_m4m5_noshield c_width=11.92u c_length=11.92u
.ends

.subckt cf2 m4_2364_280# m4_3000_1800#
Xcap_mim__21_0 m4_2364_280# m4_3000_1800# cap_mim__21
.ends

.subckt nfet__7 a_4038_0# a_38_n60# a_n84_0# VSUBS
X0 a_4038_0# a_38_n60# a_n84_0# VSUBS nfet_03v3 ad=0.61p pd=3.22u as=0.61p ps=3.22u w=1u l=20u
.ends

.subckt nfet__8 a_8038_0# a_38_n60# a_n84_n10# VSUBS
X0 a_8038_0# a_38_n60# a_n84_n10# VSUBS nfet_03v3 ad=0.2128p pd=1.98u as=0.2128p ps=1.98u w=0.28u l=40u
.ends

.subckt s2tail m1_8080_1463# nfet__8_0/VSUBS m1_150_330# m1_150_1586# m1_n250_550#
+ m1_4080_135# m1_n250_1750#
Xnfet__7_0 m1_4080_135# m1_150_330# m1_n250_550# nfet__8_0/VSUBS nfet__7
Xnfet__8_0 m1_8080_1463# m1_150_1586# m1_n250_1750# nfet__8_0/VSUBS nfet__8
.ends

.subckt pr2 m1_184_n450# m1_n50_n450# w_n20_n104# w_1380_n104# m1_1350_n450# m1_1584_n450#
Xpfet__16_0 w_1380_n104# w_1380_n104# m1_1584_n450# m1_1350_n450# pfet__16
Xpfet__16_1 w_n20_n104# w_n20_n104# m1_184_n450# m1_n50_n450# pfet__16
.ends

.subckt nfet__6 a_8038_0# a_38_n60# a_n84_0# VSUBS
X0 a_8038_0# a_38_n60# a_n84_0# VSUBS nfet_03v3 ad=0.305p pd=2.22u as=0.305p ps=2.22u w=0.5u l=40u
.ends

.subckt s2pair m1_8080_4285# m1_150_1630# m1_n250_350# nfet__6_3/VSUBS m1_8080_2885#
+ m1_8080_1485# m1_n250_4550# m1_n250_3150# m1_150_230# m1_150_4430# m1_150_3030#
+ m1_n250_1750# m1_8080_85#
Xnfet__6_0 m1_8080_4285# m1_150_4430# m1_n250_4550# nfet__6_3/VSUBS nfet__6
Xnfet__6_1 m1_8080_2885# m1_150_3030# m1_n250_3150# nfet__6_3/VSUBS nfet__6
Xnfet__6_2 m1_8080_1485# m1_150_1630# m1_n250_1750# nfet__6_3/VSUBS nfet__6
Xnfet__6_3 m1_8080_85# m1_150_230# m1_n250_350# nfet__6_3/VSUBS nfet__6
.ends

.subckt s2pair_r s2pair_0/m1_n250_4550# s2pair_0/m1_8080_1485# s2pair_0/m1_n250_3150#
+ s2pair_0/m1_150_4430# s2pair_0/m1_150_3030# s2pair_0/m1_150_230# s2pair_0/m1_n250_1750#
+ s2pair_0/m1_150_1630# s2pair_0/m1_n250_350# s2pair_0/m1_8080_85# s2pair_0/m1_8080_4285#
+ VSUBS s2pair_0/m1_8080_2885#
Xs2pair_0 s2pair_0/m1_8080_4285# s2pair_0/m1_150_1630# s2pair_0/m1_n250_350# VSUBS
+ s2pair_0/m1_8080_2885# s2pair_0/m1_8080_1485# s2pair_0/m1_n250_4550# s2pair_0/m1_n250_3150#
+ s2pair_0/m1_150_230# s2pair_0/m1_150_4430# s2pair_0/m1_150_3030# s2pair_0/m1_n250_1750#
+ s2pair_0/m1_8080_85# s2pair
.ends

.subckt nfet__2 a_38_n60# a_n84_0# a_3238_0# VSUBS
X0 a_3238_0# a_38_n60# a_n84_0# VSUBS nfet_03v3 ad=30.5p pd=0.10122m as=30.5p ps=0.10122m w=50u l=16u
.ends

.subckt m4a m1_n242_n496# m1_3268_9749# m1_n500_9900# VSUBS
Xnfet__2_0 m1_n500_9900# m1_n242_n496# m1_3268_9749# VSUBS nfet__2
.ends

.subckt m3b m1_n242_n496# m1_3268_9749# m1_n500_9900# VSUBS
Xnfet__2_0 m1_n500_9900# m1_n242_n496# m1_3268_9749# VSUBS nfet__2
.ends

.subckt m4b m1_n242_n496# m1_3268_9749# m1_n500_9900# VSUBS
Xnfet__2_0 m1_n500_9900# m1_n242_n496# m1_3268_9749# VSUBS nfet__2
.ends

.subckt m3a m1_n242_n496# m1_3268_9749# m1_n500_9900# VSUBS
Xnfet__2_0 m1_n500_9900# m1_n242_n496# m1_3268_9749# VSUBS nfet__2
.ends

.subckt mir m3b_0/m1_3268_9749# m3b_0/m1_n500_9900# m3a_0/m1_3268_9749# m4b_0/m1_n242_n496#
+ m3a_0/m1_n500_9900# m4b_0/VSUBS m4a_0/m1_n242_n496# m4b_0/m1_3268_9749# m3b_0/m1_n242_n496#
+ m4b_0/m1_n500_9900# m4a_0/m1_3268_9749# m3a_0/m1_n242_n496# m4a_0/m1_n500_9900#
Xm4a_0 m4a_0/m1_n242_n496# m4a_0/m1_3268_9749# m4a_0/m1_n500_9900# m4b_0/VSUBS m4a
Xm3b_0 m3b_0/m1_n242_n496# m3b_0/m1_3268_9749# m3b_0/m1_n500_9900# m4b_0/VSUBS m3b
Xm4b_0 m4b_0/m1_n242_n496# m4b_0/m1_3268_9749# m4b_0/m1_n500_9900# m4b_0/VSUBS m4b
Xm3a_0 m3a_0/m1_n242_n496# m3a_0/m1_3268_9749# m3a_0/m1_n500_9900# m4b_0/VSUBS m3a
.ends

.subckt nfet__11 a_38_n60# a_n84_0# a_138_0# VSUBS
X0 a_138_0# a_38_n60# a_n84_0# VSUBS nfet_03v3 ad=0.305p pd=2.22u as=0.305p ps=2.22u w=0.5u l=0.5u
.ends

.subckt sn_a m1_n250_350# nfet__12_0/VSUBS m1_1580_85# m1_2980_135# m1_2750_750# m1_2550_550#
+ m1_180_85# m1_1350_550# m1_1150_350# m1_n50_550#
Xnfet__11_0 m1_1350_550# m1_1150_350# m1_1580_85# nfet__12_0/VSUBS nfet__11
Xnfet__11_1 m1_n50_550# m1_n250_350# m1_180_85# nfet__12_0/VSUBS nfet__11
Xnfet__12_0 m1_2750_750# m1_2550_550# m1_2980_135# nfet__12_0/VSUBS nfet__12
.ends

.subckt amp_ch rec ref vbn vcm vg1 vcmo vg2 vrs out sw_rec sw_rec_b rst_amp vdd vss
Xsp_os_0 vdd vdd sw_rec m1_40350_44750# m1_40750_44550# m1_40350_44750# m1_40350_24950#
+ vdd vdd m1_40350_44750# vdd m1_40350_24950# sw_rec sp_os
Xcin2_0 m1_39950_40350# m1_6750_26150# cin2
Xsink1_0 vss vbn vss m1_21750_23350# sink1
Xor2_0 vdd m1_40750_44550# rst_amp m1_13150_25750# vss or2
Xct_0 m1_40350_24950# vss ct
Xcin_blk_0 m1_5950_23350# m1_1150_23350# rec ref cin_blk
Xcc1_0 m1_6750_26150# m1_29750_21750# cc1
Xpr3_0 m1_40350_39550# m1_14950_25550# m1_39950_40350# out m1_14950_25550# m1_40350_39550#
+ pr3
Xcf1_0 m1_6750_26150# m1_1150_23350# cf1
Xxms_0 vss vbn vss out xms
Xsp_a_0 rec vg1 m1_14950_25550# vdd m1_13150_25750# vg2 m1_5150_25350# m1_13150_25750#
+ sw_rec vcm sp_a
Xfol_0 vdd m1_28150_4550# out vss fol
Xpr1_0 m1_5550_25350# m1_5150_25350# m1_1150_23350# m1_6750_26150# m1_5150_25350#
+ m1_5550_25350# pr1
Xs2p_0 vdd m1_28150_4550# m1_37150_1950# vdd vdd m1_37150_1950# m1_37150_1950# s2p
Xota_p_0 m1_21750_23350# m1_5550_12950# m1_5950_23350# vdd m1_29750_21750# m1_21750_23350#
+ m1_1150_23350# m1_950_11350# m1_1150_23350# m1_29750_21750# m1_5550_12950# vdd m1_950_11350#
+ m1_5550_12950# m1_6750_26150# m1_5550_12950# m1_5950_23350# m1_5550_12950# ota_p
Xxm6_0 vss vss m1_6750_26150# m1_29750_21750# xm6
Xcf1p_0 vcm m1_5950_23350# cf1p
Xsn_os_0 m1_40750_44550# m1_40150_41750# vss sw_rec m1_40350_44750# vss m1_40150_41750#
+ vss m1_40350_44750# m1_40350_24950# sn_os
Xcc2_0 vss m1_28150_4550# cc2
Xcf2_0 out m1_39950_40350# cf2
Xs2tail_0 m1_40350_24950# vss vbn vbn vss m1_36350_23750# vss s2tail
Xpr2_0 m1_29150_25350# m1_5150_25350# m1_5950_23350# vcm m1_5150_25350# m1_29150_25350#
+ pr2
Xs2pair_r_0 m1_36350_23750# m1_28150_4550# m1_36350_23750# vcmo m1_39950_40350# vcmo
+ m1_36350_23750# m1_39950_40350# m1_36350_23750# m1_37150_1950# m1_37150_1950# vss
+ m1_28150_4550# s2pair_r
Xmir_0 m1_950_11350# m1_950_11350# m1_950_11350# vss m1_950_11350# vss vss m1_29750_21750#
+ vss m1_950_11350# m1_29750_21750# vss m1_950_11350# mir
Xsn_a_0 vrs vss m1_14950_25550# rec sw_rec_b vcm m1_5150_25350# m1_13150_25750# vrs
+ m1_13150_25750# sn_a
.ends

.subckt pfet__1$1 a_28_460# w_n180_n88# a_n92_0# a_94_0#
X0 a_94_0# a_28_460# a_n92_0# w_n180_n88# pfet_03v3 ad=1.3p pd=5.3u as=1.3p ps=5.3u w=2u l=0.28u
.ends

.subckt sw_p m1_n250_60# m1_140_60# m1_n50_950# w_n860_n660#
Xpfet__1$1_0 m1_n50_950# w_n860_n660# m1_n250_60# m1_140_60# pfet__1$1
.ends

.subckt cap_mim__2 m4_n120_n120# m4_0_0#
X0 m4_0_0# m4_n120_n120# cap_mim_2f0_m4m5_noshield c_width=5u c_length=5u
.ends

.subckt cap_mim__3 m4_n120_n120# m4_0_0#
X0 m4_0_0# m4_n120_n120# cap_mim_2f0_m4m5_noshield c_width=5.085u c_length=5u
.ends

.subckt dac m4_23258_9100# m4_4080_14480# m4_1480_19480# m4_18880_14480# m5_2140_9440#
+ m4_14880_14480# m4_4480_14480# m4_21480_14480# m4_1480_9080# m4_23258_16900# m4_15280_14480#
+ m4_10680_14480# m4_23258_11700# m4_9880_14480# m4_22880_14480# m4_5880_14480# m4_1480_16880#
+ m4_23258_19500# m4_12280_14480# m5_13320_15600# m4_1480_11680# m4_2880_14480# m4_16680_14480#
+ m4_20480_14480# m4_8080_14480#
Xcap_mim__2_96 m4_23258_19500# m5_13320_15600# cap_mim__2
Xcap_mim__2_74 m4_1480_19480# m5_2140_9440# cap_mim__2
Xcap_mim__2_63 m4_1480_9080# m5_2140_9440# cap_mim__2
Xcap_mim__2_52 m4_1480_9080# m5_2140_9440# cap_mim__2
Xcap_mim__2_30 m4_23258_9100# m5_13320_15600# cap_mim__2
Xcap_mim__2_41 m4_1480_11680# m5_2140_9440# cap_mim__2
Xcap_mim__2_85 m4_1480_16880# m5_2140_9440# cap_mim__2
Xcap_mim__2_97 m4_23258_19500# m5_13320_15600# cap_mim__2
Xcap_mim__2_64 m4_1480_19480# m5_2140_9440# cap_mim__2
Xcap_mim__2_75 m4_1480_19480# m5_2140_9440# cap_mim__2
Xcap_mim__2_53 m4_1480_9080# m5_2140_9440# cap_mim__2
Xcap_mim__2_31 m4_23258_9100# m5_13320_15600# cap_mim__2
Xcap_mim__2_20 m4_23258_9100# m5_13320_15600# cap_mim__2
Xcap_mim__2_42 m4_1480_11680# m5_2140_9440# cap_mim__2
Xcap_mim__2_86 m4_1480_16880# m5_2140_9440# cap_mim__2
Xcap_mim__2_98 m4_23258_19500# m5_13320_15600# cap_mim__2
Xcap_mim__2_65 m4_1480_19480# m5_2140_9440# cap_mim__2
Xcap_mim__2_76 m4_1480_19480# m5_2140_9440# cap_mim__2
Xcap_mim__2_54 m4_1480_9080# m5_2140_9440# cap_mim__2
Xcap_mim__2_21 m4_23258_9100# m5_13320_15600# cap_mim__2
Xcap_mim__2_43 m4_1480_11680# m5_2140_9440# cap_mim__2
Xcap_mim__2_10 m4_23258_11700# m5_13320_15600# cap_mim__2
Xcap_mim__2_32 m4_9880_14480# m5_2140_9440# cap_mim__2
Xcap_mim__2_87 m4_1480_16880# m5_2140_9440# cap_mim__2
Xcap_mim__2_99 m4_23258_19500# m5_13320_15600# cap_mim__2
Xcap_mim__2_66 m4_1480_19480# m5_2140_9440# cap_mim__2
Xcap_mim__2_77 m4_1480_19480# m5_2140_9440# cap_mim__2
Xcap_mim__2_55 m4_1480_9080# m5_2140_9440# cap_mim__2
Xcap_mim__2_22 m4_23258_9100# m5_13320_15600# cap_mim__2
Xcap_mim__2_44 m4_1480_11680# m5_2140_9440# cap_mim__2
Xcap_mim__2_11 m4_23258_11700# m5_13320_15600# cap_mim__2
Xcap_mim__2_33 m4_9880_14480# m5_2140_9440# cap_mim__2
Xcap_mim__2_88 m4_12280_14480# m5_2140_9440# cap_mim__2
Xcap_mim__2_67 m4_1480_19480# m5_2140_9440# cap_mim__2
Xcap_mim__2_78 m4_1480_19480# m5_2140_9440# cap_mim__2
Xcap_mim__2_56 m4_1480_9080# m5_2140_9440# cap_mim__2
Xcap_mim__2_23 m4_23258_9100# m5_13320_15600# cap_mim__2
Xcap_mim__2_45 m4_1480_11680# m5_2140_9440# cap_mim__2
Xcap_mim__2_12 m4_23258_11700# m5_13320_15600# cap_mim__2
Xcap_mim__2_34 m4_9880_14480# m5_2140_9440# cap_mim__2
Xcap_mim__2_89 m4_10680_14480# m5_2140_9440# cap_mim__2
Xcap_mim__2_68 m4_1480_19480# m5_2140_9440# cap_mim__2
Xcap_mim__2_79 m4_1480_19480# m5_2140_9440# cap_mim__2
Xcap_mim__2_57 m4_1480_9080# m5_2140_9440# cap_mim__2
Xcap_mim__2_24 m4_23258_9100# m5_13320_15600# cap_mim__2
Xcap_mim__2_46 m4_1480_11680# m5_2140_9440# cap_mim__2
Xcap_mim__2_13 m4_23258_11700# m5_13320_15600# cap_mim__2
Xcap_mim__2_35 m4_9880_14480# m5_2140_9440# cap_mim__2
Xcap_mim__2_120 m4_20480_14480# m5_13320_15600# cap_mim__2
Xcap_mim__2_69 m4_1480_19480# m5_2140_9440# cap_mim__2
Xcap_mim__2_58 m4_1480_9080# m5_2140_9440# cap_mim__2
Xcap_mim__2_25 m4_23258_9100# m5_13320_15600# cap_mim__2
Xcap_mim__2_47 m4_1480_11680# m5_2140_9440# cap_mim__2
Xcap_mim__2_14 m4_23258_11700# m5_13320_15600# cap_mim__2
Xcap_mim__2_36 m4_5880_14480# m5_2140_9440# cap_mim__2
Xcap_mim__2_110 m4_23258_19500# m5_13320_15600# cap_mim__2
Xcap_mim__2_121 m4_20480_14480# m5_13320_15600# cap_mim__2
Xcap_mim__2_59 m4_1480_9080# m5_2140_9440# cap_mim__2
Xcap_mim__2_48 m4_1480_9080# m5_2140_9440# cap_mim__2
Xcap_mim__2_26 m4_23258_9100# m5_13320_15600# cap_mim__2
Xcap_mim__2_15 m4_23258_11700# m5_13320_15600# cap_mim__2
Xcap_mim__2_37 m4_5880_14480# m5_2140_9440# cap_mim__2
Xcap_mim__2_100 m4_23258_19500# m5_13320_15600# cap_mim__2
Xcap_mim__2_111 m4_23258_19500# m5_13320_15600# cap_mim__2
Xcap_mim__2_122 m4_20480_14480# m5_13320_15600# cap_mim__2
Xcap_mim__2_49 m4_1480_9080# m5_2140_9440# cap_mim__2
Xcap_mim__2_27 m4_23258_9100# m5_13320_15600# cap_mim__2
Xcap_mim__2_16 m4_23258_9100# m5_13320_15600# cap_mim__2
Xcap_mim__2_38 m4_4480_14480# m5_2140_9440# cap_mim__2
Xcap_mim__2_101 m4_23258_19500# m5_13320_15600# cap_mim__2
Xcap_mim__2_123 m4_20480_14480# m5_13320_15600# cap_mim__2
Xcap_mim__2_112 m4_23258_16900# m5_13320_15600# cap_mim__2
Xcap_mim__2_28 m4_23258_9100# m5_13320_15600# cap_mim__2
Xcap_mim__2_17 m4_23258_9100# m5_13320_15600# cap_mim__2
Xcap_mim__2_39 m4_2880_14480# m5_2140_9440# cap_mim__2
Xcap_mim__2_102 m4_23258_19500# m5_13320_15600# cap_mim__2
Xcap_mim__2_124 m4_16680_14480# m5_13320_15600# cap_mim__2
Xcap_mim__2_113 m4_23258_16900# m5_13320_15600# cap_mim__2
Xcap_mim__2_0 m4_22880_14480# m5_13320_15600# cap_mim__2
Xcap_mim__2_29 m4_23258_9100# m5_13320_15600# cap_mim__2
Xcap_mim__2_18 m4_23258_9100# m5_13320_15600# cap_mim__2
Xcap_mim__2_103 m4_23258_19500# m5_13320_15600# cap_mim__2
Xcap_mim__2_1 m4_21480_14480# m5_13320_15600# cap_mim__2
Xcap_mim__2_125 m4_16680_14480# m5_13320_15600# cap_mim__2
Xcap_mim__2_114 m4_23258_16900# m5_13320_15600# cap_mim__2
Xcap_mim__2_19 m4_23258_9100# m5_13320_15600# cap_mim__2
Xcap_mim__2_104 m4_23258_19500# m5_13320_15600# cap_mim__2
Xcap_mim__2_2 m4_18880_14480# m5_13320_15600# cap_mim__2
Xcap_mim__2_126 m4_15280_14480# m5_13320_15600# cap_mim__2
Xcap_mim__2_115 m4_23258_16900# m5_13320_15600# cap_mim__2
Xcap_mim__2_105 m4_23258_19500# m5_13320_15600# cap_mim__2
Xcap_mim__2_3 m4_18880_14480# m5_13320_15600# cap_mim__2
Xcap_mim__2_116 m4_23258_16900# m5_13320_15600# cap_mim__2
Xcap_mim__2_106 m4_23258_19500# m5_13320_15600# cap_mim__2
Xcap_mim__2_4 m4_14880_14480# m5_13320_15600# cap_mim__2
Xcap_mim__2_117 m4_23258_16900# m5_13320_15600# cap_mim__2
Xcap_mim__2_107 m4_23258_19500# m5_13320_15600# cap_mim__2
Xcap_mim__2_5 m4_14880_14480# m5_13320_15600# cap_mim__2
Xcap_mim__2_118 m4_23258_16900# m5_13320_15600# cap_mim__2
Xcap_mim__2_108 m4_23258_19500# m5_13320_15600# cap_mim__2
Xcap_mim__2_6 m4_14880_14480# m5_13320_15600# cap_mim__2
Xcap_mim__2_119 m4_23258_16900# m5_13320_15600# cap_mim__2
Xcap_mim__2_109 m4_23258_19500# m5_13320_15600# cap_mim__2
Xcap_mim__2_7 m4_14880_14480# m5_13320_15600# cap_mim__2
Xcap_mim__2_8 m4_23258_11700# m5_13320_15600# cap_mim__2
Xcap_mim__2_9 m4_23258_11700# m5_13320_15600# cap_mim__2
Xcap_mim__3_0 m5_2140_9440# m5_13320_15600# cap_mim__3
Xcap_mim__2_90 m4_8080_14480# m5_2140_9440# cap_mim__2
Xcap_mim__2_91 m4_8080_14480# m5_2140_9440# cap_mim__2
Xcap_mim__2_80 m4_1480_16880# m5_2140_9440# cap_mim__2
Xcap_mim__2_70 m4_1480_19480# m5_2140_9440# cap_mim__2
Xcap_mim__2_92 m4_4080_14480# m5_2140_9440# cap_mim__2
Xcap_mim__2_81 m4_1480_16880# m5_2140_9440# cap_mim__2
Xcap_mim__2_71 m4_1480_19480# m5_2140_9440# cap_mim__2
Xcap_mim__2_60 m4_1480_9080# m5_2140_9440# cap_mim__2
Xcap_mim__2_93 m4_4080_14480# m5_2140_9440# cap_mim__2
Xcap_mim__2_82 m4_1480_16880# m5_2140_9440# cap_mim__2
Xcap_mim__2_72 m4_1480_19480# m5_2140_9440# cap_mim__2
Xcap_mim__2_61 m4_1480_9080# m5_2140_9440# cap_mim__2
Xcap_mim__2_50 m4_1480_9080# m5_2140_9440# cap_mim__2
Xcap_mim__2_94 m4_4080_14480# m5_2140_9440# cap_mim__2
Xcap_mim__2_83 m4_1480_16880# m5_2140_9440# cap_mim__2
Xcap_mim__2_73 m4_1480_19480# m5_2140_9440# cap_mim__2
Xcap_mim__2_62 m4_1480_9080# m5_2140_9440# cap_mim__2
Xcap_mim__2_51 m4_1480_9080# m5_2140_9440# cap_mim__2
Xcap_mim__2_40 m4_1480_11680# m5_2140_9440# cap_mim__2
Xcap_mim__2_95 m4_4080_14480# m5_2140_9440# cap_mim__2
Xcap_mim__2_84 m4_1480_16880# m5_2140_9440# cap_mim__2
.ends

.subckt nfet__0 a_30_260# a_n84_0# a_94_0# VSUBS
X0 a_94_0# a_30_260# a_n84_0# VSUBS nfet_03v3 ad=0.61p pd=3.22u as=0.61p ps=3.22u w=1u l=0.28u
.ends

.subckt sw_n m1_n250_61# m1_n50_750# nfet__0_0/VSUBS m1_136_61#
Xnfet__0_0 m1_n50_750# m1_n250_61# m1_136_61# nfet__0_0/VSUBS nfet__0
.ends

.subckt vh_seg a_12500_0# a_n128_0# VSUBS
X0 a_n128_0# a_12500_0# VSUBS ppolyf_u_1k r_width=1u r_length=62.5u
.ends

.subckt vhalf_res m1_n1050_490# m1_n650_2690# m1_n650_50# VSUBS
Xvh_seg_0 m1_12542_2250# m1_n650_2690# VSUBS vh_seg
Xvh_seg_2 m1_12542_2250# m1_n342_1370# VSUBS vh_seg
Xvh_seg_1 m1_12542_1810# m1_n650_2690# VSUBS vh_seg
Xvh_seg_3 m1_12542_1810# m1_n142_930# VSUBS vh_seg
Xvh_seg_4 m1_12542_490# m1_n342_1370# VSUBS vh_seg
Xvh_seg_5 m1_12542_50# m1_n142_930# VSUBS vh_seg
Xvh_seg_6 m1_12542_490# m1_n1050_490# VSUBS vh_seg
Xvh_seg_7 m1_12542_50# m1_n650_50# VSUBS vh_seg
.ends

.subckt row_b2 m1_1550_950# m1_5550_950# m1_9550_950# m1_1350_60# m1_6150_60# m1_2950_60#
+ m1_7750_60# m1_4140_60# m1_n250_60# m1_5740_60# m1_140_60# m1_3150_950# m1_7150_950#
+ m1_750_950# m1_5350_60# m1_6950_60# m1_3340_60# m1_4750_950# m1_8140_60# m1_4940_60#
+ m1_8750_950# m1_940_60# m1_9740_60# m1_n50_950# m1_4550_60# m1_2350_950# m1_9350_60#
+ m1_2540_60# m1_550_60# m1_6350_950# m1_7340_60# w_n860_n660# m1_8940_60# m1_7950_950#
+ m1_3950_950# m1_2150_60# m1_3750_60# m1_8550_60# m1_1740_60# m1_6540_60#
Xpfet__1$1_10 m1_1550_950# w_n860_n660# m1_1350_60# m1_1740_60# pfet__1$1
Xpfet__1$1_12 m1_n50_950# w_n860_n660# m1_n250_60# m1_140_60# pfet__1$1
Xpfet__1$1_11 m1_750_950# w_n860_n660# m1_550_60# m1_940_60# pfet__1$1
Xpfet__1$1_0 m1_9550_950# w_n860_n660# m1_9350_60# m1_9740_60# pfet__1$1
Xpfet__1$1_1 m1_8750_950# w_n860_n660# m1_8550_60# m1_8940_60# pfet__1$1
Xpfet__1$1_2 m1_7950_950# w_n860_n660# m1_7750_60# m1_8140_60# pfet__1$1
Xpfet__1$1_3 m1_7150_950# w_n860_n660# m1_6950_60# m1_7340_60# pfet__1$1
Xpfet__1$1_4 m1_6350_950# w_n860_n660# m1_6150_60# m1_6540_60# pfet__1$1
Xpfet__1$1_5 m1_5550_950# w_n860_n660# m1_5350_60# m1_5740_60# pfet__1$1
Xpfet__1$1_7 m1_3950_950# w_n860_n660# m1_3750_60# m1_4140_60# pfet__1$1
Xpfet__1$1_6 m1_4750_950# w_n860_n660# m1_4550_60# m1_4940_60# pfet__1$1
Xpfet__1$1_8 m1_3150_950# w_n860_n660# m1_2950_60# m1_3340_60# pfet__1$1
Xpfet__1$1_9 m1_2350_950# w_n860_n660# m1_2150_60# m1_2540_60# pfet__1$1
.ends

.subckt cap_mim__11 m4_n120_n120# m4_0_0#
X0 m4_0_0# m4_n120_n120# cap_mim_2f0_m4m5_noshield c_width=22.18u c_length=22.18u
.ends

.subckt vh_cap m4_4536_100# m4_5080_680#
Xcap_mim__11_0 m4_4536_100# m4_5080_680# cap_mim__11
.ends

.subckt row_a m1_13150_61# m1_16750_750# m1_750_750# m1_15536_61# m1_936_61# m1_1350_750#
+ m1_14136_61# m1_8950_61# m1_16150_750# m1_9936_61# m1_7550_61# m1_3736_61# m1_8536_61#
+ m1_6150_61# m1_2336_61# m1_4150_750# m1_7136_61# m1_3550_750# m1_n50_750# m1_6950_750#
+ nfet__0_9/VSUBS m1_1950_61# m1_6350_750# m1_14936_61# m1_12550_750# m1_17350_61#
+ m1_13536_61# m1_2936_61# m1_11950_750# m1_9750_750# m1_12136_61# m1_1536_61# m1_9150_750#
+ m1_7936_61# m1_15350_750# m1_6536_61# m1_14750_750# m1_5136_61# m1_11750_61# m1_2750_750#
+ m1_12736_61# m1_10350_61# m1_17550_750# m1_11336_61# m1_550_61# m1_2150_750# m1_17736_61#
+ m1_4750_61# m1_5550_750# m1_5736_61# m1_3350_61# m1_136_61# m1_4950_750# m1_16336_61#
+ m1_4336_61# m1_11150_750# m1_10550_750# m1_8350_750# m1_13950_750# m1_7750_750#
+ m1_9336_61# m1_15950_61# m1_16936_61# m1_14550_61# m1_10736_61# m1_13350_750#
Xnfet__0_22 m1_2150_750# m1_1950_61# m1_2336_61# nfet__0_9/VSUBS nfet__0
Xnfet__0_11 m1_9750_750# nfet__0_9/VSUBS m1_9936_61# nfet__0_9/VSUBS nfet__0
Xnfet__0_23 m1_1350_750# nfet__0_9/VSUBS m1_1536_61# nfet__0_9/VSUBS nfet__0
Xnfet__0_12 m1_9150_750# m1_8950_61# m1_9336_61# nfet__0_9/VSUBS nfet__0
Xnfet__0_24 m1_750_750# m1_550_61# m1_936_61# nfet__0_9/VSUBS nfet__0
Xnfet__0_13 m1_8350_750# nfet__0_9/VSUBS m1_8536_61# nfet__0_9/VSUBS nfet__0
Xnfet__0_25 m1_n50_750# nfet__0_9/VSUBS m1_136_61# nfet__0_9/VSUBS nfet__0
Xnfet__0_14 m1_7750_750# m1_7550_61# m1_7936_61# nfet__0_9/VSUBS nfet__0
Xnfet__0_15 m1_6950_750# nfet__0_9/VSUBS m1_7136_61# nfet__0_9/VSUBS nfet__0
Xnfet__0_17 m1_5550_750# nfet__0_9/VSUBS m1_5736_61# nfet__0_9/VSUBS nfet__0
Xnfet__0_16 m1_6350_750# m1_6150_61# m1_6536_61# nfet__0_9/VSUBS nfet__0
Xnfet__0_18 m1_4950_750# m1_4750_61# m1_5136_61# nfet__0_9/VSUBS nfet__0
Xnfet__0_19 m1_4150_750# nfet__0_9/VSUBS m1_4336_61# nfet__0_9/VSUBS nfet__0
Xnfet__0_0 m1_17550_750# m1_17350_61# m1_17736_61# nfet__0_9/VSUBS nfet__0
Xnfet__0_1 m1_16750_750# nfet__0_9/VSUBS m1_16936_61# nfet__0_9/VSUBS nfet__0
Xnfet__0_3 m1_15350_750# nfet__0_9/VSUBS m1_15536_61# nfet__0_9/VSUBS nfet__0
Xnfet__0_2 m1_16150_750# m1_15950_61# m1_16336_61# nfet__0_9/VSUBS nfet__0
Xnfet__0_4 m1_14750_750# m1_14550_61# m1_14936_61# nfet__0_9/VSUBS nfet__0
Xnfet__0_5 m1_13950_750# nfet__0_9/VSUBS m1_14136_61# nfet__0_9/VSUBS nfet__0
Xnfet__0_6 m1_13350_750# m1_13150_61# m1_13536_61# nfet__0_9/VSUBS nfet__0
Xnfet__0_7 m1_12550_750# nfet__0_9/VSUBS m1_12736_61# nfet__0_9/VSUBS nfet__0
Xnfet__0_8 m1_11950_750# m1_11750_61# m1_12136_61# nfet__0_9/VSUBS nfet__0
Xnfet__0_9 m1_11150_750# nfet__0_9/VSUBS m1_11336_61# nfet__0_9/VSUBS nfet__0
Xnfet__0_20 m1_3550_750# m1_3350_61# m1_3736_61# nfet__0_9/VSUBS nfet__0
Xnfet__0_21 m1_2750_750# nfet__0_9/VSUBS m1_2936_61# nfet__0_9/VSUBS nfet__0
Xnfet__0_10 m1_10550_750# m1_10350_61# m1_10736_61# nfet__0_9/VSUBS nfet__0
.ends

.subckt pfet__10 a_n92_0# a_62_n60# w_n214_n122# a_162_0#
X0 a_162_0# a_62_n60# a_n92_0# w_n214_n122# pfet_05v0 ad=0.9394p pd=3.98u as=0.9394p ps=3.98u w=1.22u l=0.5u
.ends

.subckt iv_p w_n860_n860# m1_74_377# m1_232_33#
Xpfet__10_0 w_n860_n860# m1_74_377# w_n860_n860# m1_232_33# pfet__10
.ends

.subckt nfet__13 a_n84_0# a_94_0# a_30_160# VSUBS
X0 a_94_0# a_30_160# a_n84_0# VSUBS nfet_03v3 ad=0.305p pd=2.22u as=0.305p ps=2.22u w=0.5u l=0.28u
.ends

.subckt xr0 m1_136_11# nfet__13_0/VSUBS m1_n250_11# m1_n50_550#
Xnfet__13_0 m1_n250_11# m1_136_11# m1_n50_550# nfet__13_0/VSUBS nfet__13
.ends

.subckt nfet__9 a_182_0# a_n84_0# a_62_n60# VSUBS
X0 a_182_0# a_62_n60# a_n84_0# VSUBS nfet_05v0 ad=0.5986p pd=3.1u as=0.5986p ps=3.1u w=0.82u l=0.6u
.ends

.subckt iv_n nfet__9_0/VSUBS m1_248_43# m1_84_295#
Xnfet__9_0 m1_248_43# nfet__9_0/VSUBS m1_84_295# nfet__9_0/VSUBS nfet__9
.ends

.subckt row_b1 m1_1940_60# m1_6740_60# m1_5540_60# m1_140_60# m1_4340_60# m1_7150_950#
+ m1_6550_950# m1_5950_950# m1_3140_60# m1_5350_950# m1_740_60# m1_4750_950# m1_4940_60#
+ m1_4150_950# m1_3550_950# m1_3740_60# m1_2950_950# m1_2350_950# m1_2540_60# m1_1750_950#
+ m1_7340_60# m1_550_950# w_n860_n660# m1_1150_950# m1_1340_60# m1_6140_60#
Xpfet__1$1_10 m1_1150_950# w_n860_n660# w_n860_n660# m1_1340_60# pfet__1$1
Xpfet__1$1_12 w_n860_n660# w_n860_n660# w_n860_n660# m1_140_60# pfet__1$1
Xpfet__1$1_11 m1_550_950# w_n860_n660# w_n860_n660# m1_740_60# pfet__1$1
Xpfet__1$1_0 m1_7150_950# w_n860_n660# w_n860_n660# m1_7340_60# pfet__1$1
Xpfet__1$1_1 m1_6550_950# w_n860_n660# w_n860_n660# m1_6740_60# pfet__1$1
Xpfet__1$1_2 m1_5950_950# w_n860_n660# w_n860_n660# m1_6140_60# pfet__1$1
Xpfet__1$1_3 m1_5350_950# w_n860_n660# w_n860_n660# m1_5540_60# pfet__1$1
Xpfet__1$1_4 m1_4750_950# w_n860_n660# w_n860_n660# m1_4940_60# pfet__1$1
Xpfet__1$1_5 m1_4150_950# w_n860_n660# w_n860_n660# m1_4340_60# pfet__1$1
Xpfet__1$1_7 m1_2950_950# w_n860_n660# w_n860_n660# m1_3140_60# pfet__1$1
Xpfet__1$1_6 m1_3550_950# w_n860_n660# w_n860_n660# m1_3740_60# pfet__1$1
Xpfet__1$1_8 m1_2350_950# w_n860_n660# w_n860_n660# m1_2540_60# pfet__1$1
Xpfet__1$1_9 m1_1750_950# w_n860_n660# w_n860_n660# m1_1940_60# pfet__1$1
.ends

.subckt cxa_x m4_1100_100# m4_1480_680#
Xcap_mim__2_0 m4_1100_100# m4_1480_680# cap_mim__2
.ends

.subckt nfet__7$1 a_30_860# a_n84_0# a_94_0# VSUBS
X0 a_94_0# a_30_860# a_n84_0# VSUBS nfet_03v3 ad=2.44p pd=9.22u as=2.44p ps=9.22u w=4u l=0.28u
.ends

.subckt nfet__6$1 a_38_n60# a_n84_0# a_138_0# VSUBS
X0 a_138_0# a_38_n60# a_n84_0# VSUBS nfet_03v3 ad=4.88p pd=17.22u as=4.88p ps=17.22u w=8u l=0.5u
.ends

.subckt nfet__5$1 a_n84_0# a_94_0# a_30_460# VSUBS
X0 a_94_0# a_30_460# a_n84_0# VSUBS nfet_03v3 ad=1.22p pd=5.22u as=1.22p ps=5.22u w=2u l=0.28u
.ends

.subckt cn_x m1_1736_56# m1_2536_61# m1_3150_950# nfet__0_0/VSUBS m1_2350_750# m1_n50_950#
+ m1_1350_56# m1_1550_1350# m1_136_60# m1_750_2150# m1_980_48# m1_3336_60#
Xnfet__7$1_0 m1_1550_1350# m1_1350_56# m1_1736_56# nfet__0_0/VSUBS nfet__7$1
Xnfet__0_0 m1_2350_750# nfet__0_0/VSUBS m1_2536_61# nfet__0_0/VSUBS nfet__0
Xnfet__6$1_0 m1_750_2150# nfet__0_0/VSUBS m1_980_48# nfet__0_0/VSUBS nfet__6$1
Xnfet__5$1_1 nfet__0_0/VSUBS m1_136_60# m1_n50_950# nfet__0_0/VSUBS nfet__5$1
Xnfet__5$1_0 nfet__0_0/VSUBS m1_3336_60# m1_3150_950# nfet__0_0/VSUBS nfet__5$1
.ends

.subckt pfet__8 w_n180_n88# a_n92_0# a_94_0# a_28_860#
X0 a_94_0# a_28_860# a_n92_0# w_n180_n88# pfet_03v3 ad=2.6p pd=9.3u as=2.6p ps=9.3u w=4u l=0.28u
.ends

.subckt cp_x m1_1550_950# m1_2540_56# m1_750_950# m1_940_60# m1_2350_1350# w_n860_n660#
+ m1_140_56# m1_n50_1350# m1_1740_60#
Xpfet__8_0 w_n860_n660# w_n860_n660# m1_2540_56# m1_2350_1350# pfet__8
Xpfet__8_1 w_n860_n660# w_n860_n660# m1_140_56# m1_n50_1350# pfet__8
Xpfet__1$1_0 m1_1550_950# w_n860_n660# w_n860_n660# m1_1740_60# pfet__1$1
Xpfet__1$1_1 m1_750_950# w_n860_n660# w_n860_n660# m1_940_60# pfet__1$1
.ends

.subckt pfet__4 a_750_0# a_546_0# a_446_n60# a_242_n60# a_954_0# w_n180_n88# a_38_n60#
+ a_n92_0# a_854_n60# a_342_0# a_138_0# a_650_n60#
X0 a_954_0# a_854_n60# a_750_0# w_n180_n88# pfet_03v3 ad=10.4p pd=33.3u as=4.16p ps=16.52u w=16u l=0.5u
X1 a_342_0# a_242_n60# a_138_0# w_n180_n88# pfet_03v3 ad=4.16p pd=16.52u as=4.16p ps=16.52u w=16u l=0.5u
X2 a_546_0# a_446_n60# a_342_0# w_n180_n88# pfet_03v3 ad=4.16p pd=16.52u as=4.16p ps=16.52u w=16u l=0.5u
X3 a_138_0# a_38_n60# a_n92_0# w_n180_n88# pfet_03v3 ad=4.16p pd=16.52u as=10.4p ps=33.3u w=16u l=0.5u
X4 a_750_0# a_650_n60# a_546_0# w_n180_n88# pfet_03v3 ad=4.16p pd=16.52u as=4.16p ps=16.52u w=16u l=0.5u
.ends

.subckt pair_x w_n1060_n1060# m1_n84_n498# m1_n500_3100# m1_140_2930#
Xpfet__4_0 m1_n84_n498# m1_140_2930# m1_n500_3100# m1_n500_3100# m1_140_2930# w_n1060_n1060#
+ m1_n500_3100# m1_n84_n498# m1_n500_3100# m1_n84_n498# m1_140_2930# m1_n500_3100#
+ pfet__4
.ends

.subckt cmp_side m1_1350_5750# m1_6150_4350# m1_750_1550# m1_950_5950# m1_3750_5750#
+ m1_1750_5550# m1_550_4150# m1_6550_750# VSUBS
Xcxa_x_0 VSUBS m1_1150_1350# cxa_x
Xcn_x_0 m1_1350_5750# m1_2950_5350# m1_2950_5350# VSUBS m1_1350_5750# m1_750_1550#
+ m1_1950_2550# m1_950_5950# m1_1150_1350# m1_1150_1350# m1_1950_2550# m1_3750_5750#
+ cn_x
Xcp_x_0 m1_1350_5750# m1_3750_5750# m1_1750_5550# m1_1350_5750# m1_2950_5350# m1_550_4150#
+ m1_1350_5750# m1_950_5950# m1_2950_5350# cp_x
Xpair_x_0 m1_550_4150# m1_6550_750# m1_6150_4350# m1_1150_1350# pair_x
.ends

.subckt cc_p m1_750_950# m1_940_60# w_n860_n660# m1_140_56# m1_n50_1350#
Xpfet__8_0 w_n860_n660# w_n860_n660# m1_140_56# m1_n50_1350# pfet__8
Xpfet__1$1_0 m1_750_950# w_n860_n660# w_n860_n660# m1_940_60# pfet__1$1
.ends

.subckt cc_n m1_n50_750# nfet__0_0/VSUBS m1_136_61#
Xnfet__0_0 m1_n50_750# nfet__0_0/VSUBS m1_136_61# nfet__0_0/VSUBS nfet__0
.ends

.subckt cmp_blk m1_n50_6150# m3_10350_550# m1_n650_1550# m3_n10450_6350# m3_10350_6350#
+ VSUBS
Xcmp_side_0 m3_n1850_2350# m3_n10450_6350# m1_n250_3350# m3_n1650_2750# cmp_side_0/m1_3750_5750#
+ m1_n50_6150# m1_n650_1550# m1_150_3150# VSUBS cmp_side
Xcc_p_0 m1_n50_6150# m1_n250_3350# m1_n650_1550# m1_150_3150# m1_n250_3350# cc_p
Xcmp_side_1 m3_n1650_2750# m3_10350_6350# m1_n250_3350# m3_n1850_2350# m3_10350_550#
+ m1_n50_6150# m1_n650_1550# m1_150_3150# VSUBS cmp_side
Xcc_n_0 m1_n50_6150# VSUBS m1_n250_3350# cc_n
.ends

.subckt xr1 m1_136_11# nfet__13_0/VSUBS m1_n250_11# m1_n50_550#
Xnfet__13_0 m1_n250_11# m1_136_11# m1_n50_550# nfet__13_0/VSUBS nfet__13
.ends

.subckt cap_mim__12 m4_n120_n120# m4_0_0#
X0 m4_0_0# m4_n120_n120# cap_mim_2f0_m4m5_noshield c_width=59.07u c_length=59.07u
.ends

.subckt cref m4_n720_11280# cap_mim__12_0/m4_0_0#
Xcap_mim__12_0 m4_n720_11280# cap_mim__12_0/m4_0_0# cap_mim__12
.ends

.subckt adc_ch vin rst_sw tg_on dac_gdn cmp_clk cmp_q dac_gp[11] dac_gn[11] dac_gp[10]
+ dac_gn[10] dac_gp[9] dac_gn[9] dac_gp[8] dac_gn[8] dac_gp[7] dac_gn[7] dac_gp[6]
+ dac_gn[6] dac_gp[5] dac_gn[5] dac_gp[4] dac_gn[4] dac_gp[3] dac_gn[3] dac_gp[2]
+ dac_gn[2] dac_gp[1] dac_gn[1] dac_gp[0] dac_gn[0] vdd_cmp vdd_dac vdd vss
Xsw_p_0 m1_750_7550# m3_43150_7550# m1_11750_4550# vdd sw_p
Xdac_0 m1_9750_4350# m1_4950_4350# m1_6150_4350# m1_7950_4350# m1_1350_7550# m1_8550_4350#
+ m1_3750_4350# m1_7350_4350# m1_6150_4350# m1_9150_4350# m1_7350_4350# m1_3750_4350#
+ m1_9150_4350# m1_4950_4350# m1_6750_4350# m1_4350_4350# m1_5550_4350# m1_9750_4350#
+ m1_3150_4350# m1_21750_7550# m1_5550_4350# m1_2350_1550# m1_7950_4350# m1_8550_4350#
+ m1_4350_4350# dac
Xsw_n_0 m1_750_7550# tg_on vss m3_43150_7550# sw_n
Xvhalf_res_0 vss m1_750_7550# vdd vss vhalf_res
Xrow_b2_0 m1_11750_4550# m1_11750_4550# m1_11750_4550# vin vin vin vin m1_5550_4350#
+ vin m1_6750_4350# m1_2350_1550# m1_11750_4550# m1_11750_4550# m1_11750_4550# vin
+ vin m1_4950_4350# m1_11750_4550# m1_8550_4350# m1_6150_4350# m1_11750_4550# m1_3150_4350#
+ m1_9750_4350# m1_11750_4550# vin m1_11750_4550# vin m1_4350_4350# vin m1_11750_4550#
+ m1_7950_4350# vdd m1_9150_4350# m1_11750_4550# m1_11750_4550# vin vin vin m1_3750_4350#
+ m1_7350_4350# row_b2
Xvh_cap_0 vss m1_750_7550# vh_cap
Xrow_a_0 vin dac_gn[11] tg_on m1_9150_4350# m1_2350_1550# dac_gn[0] m1_8550_4350#
+ vin tg_on m1_6750_4350# vin m1_3750_4350# m1_6150_4350# vin m1_3150_4350# dac_gn[2]
+ m1_5550_4350# tg_on dac_gdn dac_gn[4] vss vin tg_on m1_8550_4350# dac_gn[8] vin
+ m1_7950_4350# m1_3750_4350# tg_on dac_gn[6] m1_7350_4350# m1_3150_4350# tg_on m1_5550_4350#
+ dac_gn[10] m1_4950_4350# tg_on m1_4350_4350# vin dac_gn[1] m1_7950_4350# vin tg_on
+ m1_7350_4350# vin tg_on m1_9750_4350# vin dac_gn[3] m1_4950_4350# vin m1_2350_1550#
+ tg_on m1_9150_4350# m1_4350_4350# dac_gn[7] tg_on dac_gn[5] dac_gn[9] tg_on m1_6150_4350#
+ vin m1_9750_4350# vin m1_6750_4350# tg_on row_a
Xiv_p_0 vdd tg_on m1_11750_4550# iv_p
Xxr0_0 m1_21750_7550# vss m1_750_7550# rst_sw xr0
Xiv_n_0 vss m1_11750_4550# tg_on iv_n
Xrow_b1_0 m1_4350_4350# m1_9150_4350# m1_7950_4350# m1_2350_1550# m1_6750_4350# dac_gp[11]
+ dac_gp[10] dac_gp[9] m1_5550_4350# dac_gp[8] m1_3150_4350# dac_gp[7] m1_7350_4350#
+ dac_gp[6] dac_gp[5] m1_6150_4350# dac_gp[4] dac_gp[3] m1_4950_4350# dac_gp[2] m1_9750_4350#
+ dac_gp[0] vdd_dac dac_gp[1] m1_3750_4350# m1_8550_4350# row_b1
Xcmp_blk_0 cmp_clk cmp_q vdd_cmp m1_21750_7550# m3_43150_7550# vss cmp_blk
Xxr1_0 m1_1350_7550# vss m1_750_7550# rst_sw xr1
Xcref_0 vss m3_43150_7550# cref
.ends

.subckt TGATE VDD VSS IN OUT C CBAR
X0 OUT CBAR IN VDD pfet_05v0 ad=1.2078p pd=4.42u as=1.1712p ps=4.36u w=1.22u l=0.6u
X1 OUT C IN VSS nfet_05v0 ad=0.5876p pd=3.21u as=0.5424p ps=3.05u w=0.565u l=0.6u
.ends

.subckt afe_ch e rec ipg ref vbn vcm vg1 vcmo vg2 vrs sw_rec sw_rec_b sw_ipg sw_ipg_b
+ rst_amp rst_sw tg_on dac_gdn cmp_clk cmp_q dac_gp[11] dac_gn[11] dac_gp[10] dac_gn[10]
+ dac_gp[9] dac_gn[9] dac_gp[8] dac_gn[8] dac_gp[7] dac_gn[7] dac_gp[6] dac_gn[6]
+ dac_gp[5] dac_gn[5] dac_gp[4] dac_gn[4] dac_gp[3] dac_gn[3] dac_gp[2] dac_gn[2]
+ dac_gp[1] dac_gn[1] dac_gp[0] dac_gn[0] vdd vdd_dac vdd_cmp vss
Xamp_ch_0 rec ref vbn vcm vg1 vcmo vg2 vrs amp_ch_0/out sw_rec sw_rec_b rst_amp vdd
+ vss amp_ch
Xadc_ch_0 amp_ch_0/out rst_sw tg_on dac_gdn cmp_clk cmp_q dac_gp[11] dac_gn[11] dac_gp[10]
+ dac_gn[10] dac_gp[9] dac_gn[9] dac_gp[8] dac_gn[8] dac_gp[7] dac_gn[7] dac_gp[6]
+ dac_gn[6] dac_gp[5] dac_gn[5] dac_gp[4] dac_gn[4] dac_gp[3] dac_gn[3] dac_gp[2]
+ dac_gn[2] dac_gp[1] dac_gn[1] dac_gp[0] dac_gn[0] vdd_cmp vdd_dac vdd vss adc_ch
XTGATE_0 vdd vss e ipg sw_ipg sw_ipg_b TGATE
XTGATE_1 vdd vss e rec sw_rec sw_rec_b TGATE
.ends

.subckt gf180mcu_fd_sc_mcu7t5v0__fillcap_8$1 VDD VSS VNW VPW
X0 VDD a_572_375# a_484_472# VNW pfet_05v0 ad=0.5368p pd=3.32u as=0.5368p ps=3.32u w=1.22u l=1u
X1 a_572_375# a_484_472# VSS VPW nfet_05v0 ad=0.3608p pd=2.52u as=0.3608p ps=2.52u w=0.82u l=1u
X2 a_124_375# a_36_472# VSS VPW nfet_05v0 ad=0.3608p pd=2.52u as=0.3608p ps=2.52u w=0.82u l=1u
X3 VDD a_124_375# a_36_472# VNW pfet_05v0 ad=0.5368p pd=3.32u as=0.5368p ps=3.32u w=1.22u l=1u
.ends

.subckt gf180mcu_fd_sc_mcu7t5v0__fillcap_4$1 VDD VSS VNW VPW
X0 a_124_375# a_36_472# VSS VPW nfet_05v0 ad=0.3608p pd=2.52u as=0.3608p ps=2.52u w=0.82u l=1u
X1 VDD a_124_375# a_36_472# VNW pfet_05v0 ad=0.5368p pd=3.32u as=0.5368p ps=3.32u w=1.22u l=1u
.ends

.subckt gf180mcu_fd_sc_mcu7t5v0__nand2_1$1 VDD VSS ZN A1 A2 VNW VPW
X0 ZN A2 VDD VNW pfet_05v0 ad=0.2938p pd=1.65u as=0.4972p ps=3.14u w=1.13u l=0.5u
X1 ZN A1 a_245_68# VPW nfet_05v0 ad=0.3608p pd=2.52u as=0.1312p ps=1.14u w=0.82u l=0.6u
X2 VDD A1 ZN VNW pfet_05v0 ad=0.4972p pd=3.14u as=0.2938p ps=1.65u w=1.13u l=0.5u
X3 a_245_68# A2 VSS VPW nfet_05v0 ad=0.1312p pd=1.14u as=0.3608p ps=2.52u w=0.82u l=0.6u
.ends

.subckt gf180mcu_fd_sc_mcu7t5v0__nor3_1$1 A3 VDD VSS ZN A1 A2 VNW VPW
X0 ZN A1 a_448_472# VNW pfet_05v0 ad=0.5368p pd=3.32u as=0.3782p ps=1.84u w=1.22u l=0.5u
X1 ZN A1 VSS VPW nfet_05v0 ad=0.2046p pd=1.81u as=0.1209p ps=0.985u w=0.465u l=0.6u
X2 a_244_472# A3 VDD VNW pfet_05v0 ad=0.3172p pd=1.74u as=0.5368p ps=3.32u w=1.22u l=0.5u
X3 a_448_472# A2 a_244_472# VNW pfet_05v0 ad=0.3782p pd=1.84u as=0.3172p ps=1.74u w=1.22u l=0.5u
X4 VSS A2 ZN VPW nfet_05v0 ad=0.1209p pd=0.985u as=0.1209p ps=0.985u w=0.465u l=0.6u
X5 ZN A3 VSS VPW nfet_05v0 ad=0.1209p pd=0.985u as=0.2046p ps=1.81u w=0.465u l=0.6u
.ends

.subckt gf180mcu_fd_sc_mcu7t5v0__fillcap_64$1 VDD VSS VNW VPW
X0 a_4604_375# a_4516_472# VSS VPW nfet_05v0 ad=0.3608p pd=2.52u as=0.3608p ps=2.52u w=0.82u l=1u
X1 VDD a_572_375# a_484_472# VNW pfet_05v0 ad=0.5368p pd=3.32u as=0.5368p ps=3.32u w=1.22u l=1u
X2 VDD a_2364_375# a_2276_472# VNW pfet_05v0 ad=0.5368p pd=3.32u as=0.5368p ps=3.32u w=1.22u l=1u
X3 a_4156_375# a_4068_472# VSS VPW nfet_05v0 ad=0.3608p pd=2.52u as=0.3608p ps=2.52u w=0.82u l=1u
X4 a_5500_375# a_5412_472# VSS VPW nfet_05v0 ad=0.3608p pd=2.52u as=0.3608p ps=2.52u w=0.82u l=1u
X5 a_572_375# a_484_472# VSS VPW nfet_05v0 ad=0.3608p pd=2.52u as=0.3608p ps=2.52u w=0.82u l=1u
X6 VDD a_5052_375# a_4964_472# VNW pfet_05v0 ad=0.5368p pd=3.32u as=0.5368p ps=3.32u w=1.22u l=1u
X7 VDD a_6844_375# a_6756_472# VNW pfet_05v0 ad=0.5368p pd=3.32u as=0.5368p ps=3.32u w=1.22u l=1u
X8 VDD a_1916_375# a_1828_472# VNW pfet_05v0 ad=0.5368p pd=3.32u as=0.5368p ps=3.32u w=1.22u l=1u
X9 a_124_375# a_36_472# VSS VPW nfet_05v0 ad=0.3608p pd=2.52u as=0.3608p ps=2.52u w=0.82u l=1u
X10 a_5052_375# a_4964_472# VSS VPW nfet_05v0 ad=0.3608p pd=2.52u as=0.3608p ps=2.52u w=0.82u l=1u
X11 a_1916_375# a_1828_472# VSS VPW nfet_05v0 ad=0.3608p pd=2.52u as=0.3608p ps=2.52u w=0.82u l=1u
X12 VDD a_4604_375# a_4516_472# VNW pfet_05v0 ad=0.5368p pd=3.32u as=0.5368p ps=3.32u w=1.22u l=1u
X13 a_1468_375# a_1380_472# VSS VPW nfet_05v0 ad=0.3608p pd=2.52u as=0.3608p ps=2.52u w=0.82u l=1u
X14 a_2812_375# a_2724_472# VSS VPW nfet_05v0 ad=0.3608p pd=2.52u as=0.3608p ps=2.52u w=0.82u l=1u
X15 VDD a_3260_375# a_3172_472# VNW pfet_05v0 ad=0.5368p pd=3.32u as=0.5368p ps=3.32u w=1.22u l=1u
X16 a_2364_375# a_2276_472# VSS VPW nfet_05v0 ad=0.3608p pd=2.52u as=0.3608p ps=2.52u w=0.82u l=1u
X17 a_5948_375# a_5860_472# VSS VPW nfet_05v0 ad=0.3608p pd=2.52u as=0.3608p ps=2.52u w=0.82u l=1u
X18 VDD a_2812_375# a_2724_472# VNW pfet_05v0 ad=0.5368p pd=3.32u as=0.5368p ps=3.32u w=1.22u l=1u
X19 a_3260_375# a_3172_472# VSS VPW nfet_05v0 ad=0.3608p pd=2.52u as=0.3608p ps=2.52u w=0.82u l=1u
X20 VDD a_1020_375# a_932_472# VNW pfet_05v0 ad=0.5368p pd=3.32u as=0.5368p ps=3.32u w=1.22u l=1u
X21 VDD a_5500_375# a_5412_472# VNW pfet_05v0 ad=0.5368p pd=3.32u as=0.5368p ps=3.32u w=1.22u l=1u
X22 a_6844_375# a_6756_472# VSS VPW nfet_05v0 ad=0.3608p pd=2.52u as=0.3608p ps=2.52u w=0.82u l=1u
X23 a_6396_375# a_6308_472# VSS VPW nfet_05v0 ad=0.3608p pd=2.52u as=0.3608p ps=2.52u w=0.82u l=1u
X24 VDD a_6396_375# a_6308_472# VNW pfet_05v0 ad=0.5368p pd=3.32u as=0.5368p ps=3.32u w=1.22u l=1u
X25 VDD a_1468_375# a_1380_472# VNW pfet_05v0 ad=0.5368p pd=3.32u as=0.5368p ps=3.32u w=1.22u l=1u
X26 VDD a_4156_375# a_4068_472# VNW pfet_05v0 ad=0.5368p pd=3.32u as=0.5368p ps=3.32u w=1.22u l=1u
X27 VDD a_5948_375# a_5860_472# VNW pfet_05v0 ad=0.5368p pd=3.32u as=0.5368p ps=3.32u w=1.22u l=1u
X28 VDD a_124_375# a_36_472# VNW pfet_05v0 ad=0.5368p pd=3.32u as=0.5368p ps=3.32u w=1.22u l=1u
X29 a_3708_375# a_3620_472# VSS VPW nfet_05v0 ad=0.3608p pd=2.52u as=0.3608p ps=2.52u w=0.82u l=1u
X30 VDD a_3708_375# a_3620_472# VNW pfet_05v0 ad=0.5368p pd=3.32u as=0.5368p ps=3.32u w=1.22u l=1u
X31 a_1020_375# a_932_472# VSS VPW nfet_05v0 ad=0.3608p pd=2.52u as=0.3608p ps=2.52u w=0.82u l=1u
.ends

.subckt gf180mcu_fd_sc_mcu7t5v0__nor2_1$1 VDD VSS ZN A1 A2 VNW VPW
X0 ZN A1 a_224_472# VNW pfet_05v0 ad=0.5368p pd=3.32u as=0.4087p ps=1.89u w=1.22u l=0.5u
X1 VSS A1 ZN VPW nfet_05v0 ad=0.2486p pd=2.01u as=0.1469p ps=1.085u w=0.565u l=0.6u
X2 a_224_472# A2 VDD VNW pfet_05v0 ad=0.4087p pd=1.89u as=0.5368p ps=3.32u w=1.22u l=0.5u
X3 ZN A2 VSS VPW nfet_05v0 ad=0.1469p pd=1.085u as=0.2486p ps=2.01u w=0.565u l=0.6u
.ends

.subckt gf180mcu_fd_sc_mcu7t5v0__fillcap_32$1 VDD VSS VNW VPW
X0 VDD a_572_375# a_484_472# VNW pfet_05v0 ad=0.5368p pd=3.32u as=0.5368p ps=3.32u w=1.22u l=1u
X1 VDD a_2364_375# a_2276_472# VNW pfet_05v0 ad=0.5368p pd=3.32u as=0.5368p ps=3.32u w=1.22u l=1u
X2 a_572_375# a_484_472# VSS VPW nfet_05v0 ad=0.3608p pd=2.52u as=0.3608p ps=2.52u w=0.82u l=1u
X3 VDD a_1916_375# a_1828_472# VNW pfet_05v0 ad=0.5368p pd=3.32u as=0.5368p ps=3.32u w=1.22u l=1u
X4 a_124_375# a_36_472# VSS VPW nfet_05v0 ad=0.3608p pd=2.52u as=0.3608p ps=2.52u w=0.82u l=1u
X5 a_1916_375# a_1828_472# VSS VPW nfet_05v0 ad=0.3608p pd=2.52u as=0.3608p ps=2.52u w=0.82u l=1u
X6 a_1468_375# a_1380_472# VSS VPW nfet_05v0 ad=0.3608p pd=2.52u as=0.3608p ps=2.52u w=0.82u l=1u
X7 a_2812_375# a_2724_472# VSS VPW nfet_05v0 ad=0.3608p pd=2.52u as=0.3608p ps=2.52u w=0.82u l=1u
X8 VDD a_3260_375# a_3172_472# VNW pfet_05v0 ad=0.5368p pd=3.32u as=0.5368p ps=3.32u w=1.22u l=1u
X9 a_2364_375# a_2276_472# VSS VPW nfet_05v0 ad=0.3608p pd=2.52u as=0.3608p ps=2.52u w=0.82u l=1u
X10 VDD a_2812_375# a_2724_472# VNW pfet_05v0 ad=0.5368p pd=3.32u as=0.5368p ps=3.32u w=1.22u l=1u
X11 a_3260_375# a_3172_472# VSS VPW nfet_05v0 ad=0.3608p pd=2.52u as=0.3608p ps=2.52u w=0.82u l=1u
X12 VDD a_1020_375# a_932_472# VNW pfet_05v0 ad=0.5368p pd=3.32u as=0.5368p ps=3.32u w=1.22u l=1u
X13 VDD a_1468_375# a_1380_472# VNW pfet_05v0 ad=0.5368p pd=3.32u as=0.5368p ps=3.32u w=1.22u l=1u
X14 VDD a_124_375# a_36_472# VNW pfet_05v0 ad=0.5368p pd=3.32u as=0.5368p ps=3.32u w=1.22u l=1u
X15 a_1020_375# a_932_472# VSS VPW nfet_05v0 ad=0.3608p pd=2.52u as=0.3608p ps=2.52u w=0.82u l=1u
.ends

.subckt gf180mcu_fd_sc_mcu7t5v0__fillcap_16$1 VDD VSS VNW VPW
X0 VDD a_572_375# a_484_472# VNW pfet_05v0 ad=0.5368p pd=3.32u as=0.5368p ps=3.32u w=1.22u l=1u
X1 a_572_375# a_484_472# VSS VPW nfet_05v0 ad=0.3608p pd=2.52u as=0.3608p ps=2.52u w=0.82u l=1u
X2 a_124_375# a_36_472# VSS VPW nfet_05v0 ad=0.3608p pd=2.52u as=0.3608p ps=2.52u w=0.82u l=1u
X3 a_1468_375# a_1380_472# VSS VPW nfet_05v0 ad=0.3608p pd=2.52u as=0.3608p ps=2.52u w=0.82u l=1u
X4 VDD a_1020_375# a_932_472# VNW pfet_05v0 ad=0.5368p pd=3.32u as=0.5368p ps=3.32u w=1.22u l=1u
X5 VDD a_1468_375# a_1380_472# VNW pfet_05v0 ad=0.5368p pd=3.32u as=0.5368p ps=3.32u w=1.22u l=1u
X6 VDD a_124_375# a_36_472# VNW pfet_05v0 ad=0.5368p pd=3.32u as=0.5368p ps=3.32u w=1.22u l=1u
X7 a_1020_375# a_932_472# VSS VPW nfet_05v0 ad=0.3608p pd=2.52u as=0.3608p ps=2.52u w=0.82u l=1u
.ends

.subckt gf180mcu_fd_sc_mcu7t5v0__dffrnq_1$1 D Q RN VSS CLK VDD VNW VPW
X0 VSS CLK a_36_151# VPW nfet_05v0 ad=0.1053p pd=0.925u as=0.1782p ps=1.69u w=0.405u l=0.6u
X1 VSS RN a_1456_156# VPW nfet_05v0 ad=0.2016p pd=1.48u as=43.2f ps=0.6u w=0.36u l=0.6u
X2 Q a_2665_112# VDD VNW pfet_05v0 ad=0.5346p pd=3.31u as=0.5346p ps=3.31u w=1.215u l=0.5u
X3 a_796_472# D VSS VPW nfet_05v0 ad=93.59999f pd=0.88u as=0.1584p ps=1.6u w=0.36u l=0.6u
X4 VSS a_2665_112# a_2560_156# VPW nfet_05v0 ad=0.1224p pd=1.04u as=94.5f ps=0.885u w=0.36u l=0.6u
X5 a_2665_112# a_2248_156# a_3041_156# VPW nfet_05v0 ad=0.176p pd=1.68u as=0.134p ps=1.1u w=0.4u l=0.6u
X6 a_1000_472# a_448_472# a_796_472# VNW pfet_05v0 ad=0.2028p pd=1.3u as=0.2028p ps=1.3u w=0.78u l=0.5u
X7 a_2248_156# a_36_151# a_1308_423# VNW pfet_05v0 ad=0.25375p pd=1.51u as=0.2424p ps=1.465u w=0.505u l=0.5u
X8 a_2248_156# a_448_472# a_1308_423# VPW nfet_05v0 ad=0.2007p pd=1.475u as=0.2007p ps=1.475u w=0.36u l=0.6u
X9 VDD CLK a_36_151# VNW pfet_05v0 ad=0.2249p pd=1.385u as=0.3806p ps=2.61u w=0.865u l=0.5u
X10 a_1456_156# a_1308_423# a_1288_156# VPW nfet_05v0 ad=43.2f pd=0.6u as=43.2f ps=0.6u w=0.36u l=0.6u
X11 a_1308_423# a_1000_472# VSS VPW nfet_05v0 ad=0.2007p pd=1.475u as=0.2016p ps=1.48u w=0.36u l=0.6u
X12 Q a_2665_112# VSS VPW nfet_05v0 ad=0.3586p pd=2.51u as=0.3586p ps=2.51u w=0.815u l=0.6u
X13 a_448_472# a_36_151# VDD VNW pfet_05v0 ad=0.3806p pd=2.61u as=0.2249p ps=1.385u w=0.865u l=0.5u
X14 a_1204_472# a_36_151# a_1000_472# VNW pfet_05v0 ad=0.2028p pd=1.3u as=0.2028p ps=1.3u w=0.78u l=0.5u
X15 a_1204_472# RN VDD VNW pfet_05v0 ad=0.3432p pd=2.44u as=0.45p ps=2.02u w=0.78u l=0.5u
X16 a_2665_112# RN VDD VNW pfet_05v0 ad=0.26p pd=1.52u as=0.29465p ps=1.74u w=1u l=0.5u
X17 a_2560_156# a_36_151# a_2248_156# VPW nfet_05v0 ad=94.5f pd=0.885u as=0.2007p ps=1.475u w=0.36u l=0.6u
X18 VDD a_2248_156# a_2665_112# VNW pfet_05v0 ad=0.44p pd=2.88u as=0.26p ps=1.52u w=1u l=0.5u
X19 a_1288_156# a_448_472# a_1000_472# VPW nfet_05v0 ad=43.2f pd=0.6u as=93.59999f ps=0.88u w=0.36u l=0.6u
X20 VDD a_1308_423# a_1204_472# VNW pfet_05v0 ad=0.45p pd=2.02u as=0.2028p ps=1.3u w=0.78u l=0.5u
X21 a_2560_156# a_448_472# a_2248_156# VNW pfet_05v0 ad=0.1313p pd=1.025u as=0.25375p ps=1.51u w=0.505u l=0.5u
X22 a_448_472# a_36_151# VSS VPW nfet_05v0 ad=0.1782p pd=1.69u as=0.1053p ps=0.925u w=0.405u l=0.6u
X23 a_3041_156# RN VSS VPW nfet_05v0 ad=0.134p pd=1.1u as=0.1224p ps=1.04u w=0.36u l=0.6u
X24 VDD a_2665_112# a_2560_156# VNW pfet_05v0 ad=0.29465p pd=1.74u as=0.1313p ps=1.025u w=0.505u l=0.5u
X25 a_1308_423# a_1000_472# VDD VNW pfet_05v0 ad=0.2424p pd=1.465u as=0.2222p ps=1.89u w=0.505u l=0.5u
X26 a_1000_472# a_36_151# a_796_472# VPW nfet_05v0 ad=93.59999f pd=0.88u as=93.59999f ps=0.88u w=0.36u l=0.6u
X27 a_796_472# D VDD VNW pfet_05v0 ad=0.2028p pd=1.3u as=0.3432p ps=2.44u w=0.78u l=0.5u
.ends

.subckt gf180mcu_fd_sc_mcu7t5v0__oai211_1$1 B C VDD VSS ZN A1 A2 VNW VPW
X0 a_692_68# B a_36_68# VPW nfet_05v0 ad=0.2132p pd=1.34u as=0.2132p ps=1.34u w=0.82u l=0.6u
X1 ZN A2 a_36_68# VPW nfet_05v0 ad=0.2132p pd=1.34u as=0.3608p ps=2.52u w=0.82u l=0.6u
X2 a_244_472# A2 VDD VNW pfet_05v0 ad=0.3172p pd=1.74u as=0.5978p ps=3.42u w=1.22u l=0.5u
X3 VDD B ZN VNW pfet_05v0 ad=0.2561p pd=1.505u as=0.4016p ps=1.94u w=0.985u l=0.5u
X4 ZN A1 a_244_472# VNW pfet_05v0 ad=0.4016p pd=1.94u as=0.3172p ps=1.74u w=1.22u l=0.5u
X5 ZN C VDD VNW pfet_05v0 ad=0.44325p pd=2.87u as=0.2561p ps=1.505u w=0.985u l=0.5u
X6 VSS C a_692_68# VPW nfet_05v0 ad=0.3608p pd=2.52u as=0.2132p ps=1.34u w=0.82u l=0.6u
X7 a_36_68# A1 ZN VPW nfet_05v0 ad=0.2132p pd=1.34u as=0.2132p ps=1.34u w=0.82u l=0.6u
.ends

.subckt gf180mcu_fd_sc_mcu7t5v0__aoi211_1$1 B C VDD VSS ZN A1 A2 VNW VPW
X0 ZN A2 a_37_472# VNW pfet_05v0 ad=0.3159p pd=1.735u as=0.5346p ps=3.31u w=1.215u l=0.5u
X1 VSS B ZN VPW nfet_05v0 ad=0.1209p pd=0.985u as=0.21175p ps=1.41u w=0.465u l=0.6u
X2 a_37_472# A1 ZN VNW pfet_05v0 ad=0.37665p pd=1.835u as=0.3159p ps=1.735u w=1.215u l=0.5u
X3 VDD C a_653_472# VNW pfet_05v0 ad=0.5346p pd=3.31u as=0.37665p ps=1.835u w=1.215u l=0.5u
X4 a_245_90# A2 VSS VPW nfet_05v0 ad=85.2f pd=0.95u as=0.3124p ps=2.3u w=0.71u l=0.6u
X5 ZN A1 a_245_90# VPW nfet_05v0 ad=0.21175p pd=1.41u as=85.2f ps=0.95u w=0.71u l=0.6u
X6 a_653_472# B a_37_472# VNW pfet_05v0 ad=0.37665p pd=1.835u as=0.37665p ps=1.835u w=1.215u l=0.5u
X7 ZN C VSS VPW nfet_05v0 ad=0.2046p pd=1.81u as=0.1209p ps=0.985u w=0.465u l=0.6u
.ends

.subckt gf180mcu_fd_sc_mcu7t5v0__tiel$1 ZN VDD VSS VNW VPW
X0 ZN a_124_24# VSS VPW nfet_05v0 ad=0.3608p pd=2.52u as=0.3608p ps=2.52u w=0.82u l=0.6u
X1 a_124_24# a_124_24# VDD VNW pfet_05v0 ad=0.5368p pd=3.32u as=0.5368p ps=3.32u w=1.22u l=0.5u
.ends

.subckt gf180mcu_fd_sc_mcu7t5v0__and3_1$1 A3 VDD VSS Z A1 A2 VNW VPW
X0 Z a_36_148# VDD VNW pfet_05v0 ad=0.5346p pd=3.31u as=0.4268p ps=2.175u w=1.215u l=0.5u
X1 a_428_148# A2 a_244_148# VPW nfet_05v0 ad=79.8f pd=0.8u as=60.8f ps=0.7u w=0.38u l=0.6u
X2 Z a_36_148# VSS VPW nfet_05v0 ad=0.341p pd=2.43u as=0.2424p ps=1.635u w=0.775u l=0.6u
X3 VSS A3 a_428_148# VPW nfet_05v0 ad=0.2424p pd=1.635u as=79.8f ps=0.8u w=0.38u l=0.6u
X4 a_244_148# A1 a_36_148# VPW nfet_05v0 ad=60.8f pd=0.7u as=0.1672p ps=1.64u w=0.38u l=0.6u
X5 VDD A1 a_36_148# VNW pfet_05v0 ad=0.1391p pd=1.055u as=0.2354p ps=1.95u w=0.535u l=0.5u
X6 a_36_148# A2 VDD VNW pfet_05v0 ad=0.1391p pd=1.055u as=0.1391p ps=1.055u w=0.535u l=0.5u
X7 VDD A3 a_36_148# VNW pfet_05v0 ad=0.4268p pd=2.175u as=0.1391p ps=1.055u w=0.535u l=0.5u
.ends

.subckt gf180mcu_fd_sc_mcu7t5v0__oai221_1$1 B1 C VDD VSS ZN A1 A2 B2 VNW VPW
X0 a_692_68# C a_36_68# VPW nfet_05v0 ad=0.246p pd=1.42u as=0.2132p ps=1.34u w=0.82u l=0.6u
X1 a_932_472# A2 VDD VNW pfet_05v0 ad=0.3172p pd=1.74u as=0.38575p ps=1.92u w=1.22u l=0.5u
X2 VSS B2 a_36_68# VPW nfet_05v0 ad=0.2132p pd=1.34u as=0.3608p ps=2.52u w=0.82u l=0.6u
X3 ZN A2 a_692_68# VPW nfet_05v0 ad=0.2132p pd=1.34u as=0.246p ps=1.42u w=0.82u l=0.6u
X4 a_244_472# B2 VDD VNW pfet_05v0 ad=0.3172p pd=1.74u as=0.6588p ps=3.52u w=1.22u l=0.5u
X5 ZN A1 a_932_472# VNW pfet_05v0 ad=0.5368p pd=3.32u as=0.3172p ps=1.74u w=1.22u l=0.5u
X6 VDD C ZN VNW pfet_05v0 ad=0.38575p pd=1.92u as=0.3952p ps=1.94u w=0.945u l=0.5u
X7 ZN B1 a_244_472# VNW pfet_05v0 ad=0.3952p pd=1.94u as=0.3172p ps=1.74u w=1.22u l=0.5u
X8 a_36_68# B1 VSS VPW nfet_05v0 ad=0.2132p pd=1.34u as=0.2132p ps=1.34u w=0.82u l=0.6u
X9 a_692_68# A1 ZN VPW nfet_05v0 ad=0.3608p pd=2.52u as=0.2132p ps=1.34u w=0.82u l=0.6u
.ends

.subckt gf180mcu_fd_sc_mcu7t5v0__aoi21_1$1 B VDD VSS ZN A1 A2 VNW VPW
X0 a_244_68# A2 VSS VPW nfet_05v0 ad=0.1312p pd=1.14u as=0.3608p ps=2.52u w=0.82u l=0.6u
X1 ZN A1 a_244_68# VPW nfet_05v0 ad=0.2569p pd=1.56u as=0.1312p ps=1.14u w=0.82u l=0.6u
X2 VDD B a_36_472# VNW pfet_05v0 ad=0.5346p pd=3.31u as=0.44955p ps=1.955u w=1.215u l=0.5u
X3 ZN A2 a_36_472# VNW pfet_05v0 ad=0.3159p pd=1.735u as=0.5346p ps=3.31u w=1.215u l=0.5u
X4 a_36_472# A1 ZN VNW pfet_05v0 ad=0.44955p pd=1.955u as=0.3159p ps=1.735u w=1.215u l=0.5u
X5 VSS B ZN VPW nfet_05v0 ad=0.2244p pd=1.9u as=0.2569p ps=1.56u w=0.51u l=0.6u
.ends

.subckt gf180mcu_fd_sc_mcu7t5v0__and2_1$1 VDD VSS Z A1 A2 VNW VPW
X0 VDD A2 a_36_159# VNW pfet_05v0 ad=0.40575p pd=2.055u as=0.156p ps=1.12u w=0.6u l=0.5u
X1 Z a_36_159# VDD VNW pfet_05v0 ad=0.5346p pd=3.31u as=0.40575p ps=2.055u w=1.215u l=0.5u
X2 Z a_36_159# VSS VPW nfet_05v0 ad=0.3586p pd=2.51u as=0.23405p ps=1.555u w=0.815u l=0.6u
X3 VSS A2 a_244_159# VPW nfet_05v0 ad=0.23405p pd=1.555u as=58.39999f ps=0.685u w=0.365u l=0.6u
X4 a_244_159# A1 a_36_159# VPW nfet_05v0 ad=58.39999f pd=0.685u as=0.1606p ps=1.61u w=0.365u l=0.6u
X5 a_36_159# A1 VDD VNW pfet_05v0 ad=0.156p pd=1.12u as=0.264p ps=2.08u w=0.6u l=0.5u
.ends

.subckt gf180mcu_fd_sc_mcu7t5v0__nand3_1$1 A3 VDD VSS ZN A1 A2 VNW VPW
X0 ZN A1 a_455_68# VPW nfet_05v0 ad=0.3608p pd=2.52u as=0.1722p ps=1.24u w=0.82u l=0.6u
X1 ZN A3 VDD VNW pfet_05v0 ad=0.2561p pd=1.505u as=0.4334p ps=2.85u w=0.985u l=0.5u
X2 VDD A2 ZN VNW pfet_05v0 ad=0.2561p pd=1.505u as=0.2561p ps=1.505u w=0.985u l=0.5u
X3 ZN A1 VDD VNW pfet_05v0 ad=0.4334p pd=2.85u as=0.2561p ps=1.505u w=0.985u l=0.5u
X4 a_271_68# A3 VSS VPW nfet_05v0 ad=0.1312p pd=1.14u as=0.3608p ps=2.52u w=0.82u l=0.6u
X5 a_455_68# A2 a_271_68# VPW nfet_05v0 ad=0.1722p pd=1.24u as=0.1312p ps=1.14u w=0.82u l=0.6u
.ends

.subckt gf180mcu_fd_sc_mcu7t5v0__oai21_1$1 VDD B A2 ZN A1 VSS VNW VPW
X0 VSS B a_36_68# VPW nfet_05v0 ad=0.3608p pd=2.52u as=0.2132p ps=1.34u w=0.82u l=0.6u
X1 ZN A2 a_36_68# VPW nfet_05v0 ad=0.2132p pd=1.34u as=0.3608p ps=2.52u w=0.82u l=0.6u
X2 VDD B ZN VNW pfet_05v0 ad=0.4972p pd=3.14u as=0.4248p ps=1.94u w=1.13u l=0.5u
X3 a_244_472# A2 VDD VNW pfet_05v0 ad=0.3172p pd=1.74u as=0.5978p ps=3.42u w=1.22u l=0.5u
X4 ZN A1 a_244_472# VNW pfet_05v0 ad=0.4248p pd=1.94u as=0.3172p ps=1.74u w=1.22u l=0.5u
X5 a_36_68# A1 ZN VPW nfet_05v0 ad=0.2132p pd=1.34u as=0.2132p ps=1.34u w=0.82u l=0.6u
.ends

.subckt gf180mcu_fd_sc_mcu7t5v0__or3_1$1 A3 VDD VSS Z A1 A2 VNW VPW
X0 a_224_604# A1 a_36_88# VNW pfet_05v0 ad=0.1736p pd=1.18u as=0.2464p ps=2u w=0.56u l=0.5u
X1 a_36_88# A2 VSS VPW nfet_05v0 ad=0.14p pd=1.1u as=0.104p ps=0.92u w=0.4u l=0.6u
X2 Z a_36_88# VDD VNW pfet_05v0 ad=0.5368p pd=3.32u as=0.389p ps=2.02u w=1.22u l=0.5u
X3 VSS A1 a_36_88# VPW nfet_05v0 ad=0.104p pd=0.92u as=0.176p ps=1.68u w=0.4u l=0.6u
X4 a_448_604# A2 a_224_604# VNW pfet_05v0 ad=0.224p pd=1.36u as=0.1736p ps=1.18u w=0.56u l=0.5u
X5 VSS A3 a_36_88# VPW nfet_05v0 ad=0.224p pd=1.52u as=0.14p ps=1.1u w=0.4u l=0.6u
X6 VDD A3 a_448_604# VNW pfet_05v0 ad=0.389p pd=2.02u as=0.224p ps=1.36u w=0.56u l=0.5u
X7 Z a_36_88# VSS VPW nfet_05v0 ad=0.3608p pd=2.52u as=0.224p ps=1.52u w=0.82u l=0.6u
.ends

.subckt gf180mcu_fd_sc_mcu7t5v0__or2_1$2 VDD VSS Z A1 A2 VNW VPW
X0 a_255_603# A1 a_67_603# VNW pfet_05v0 ad=0.1469p pd=1.085u as=0.2486p ps=2.01u w=0.565u l=0.5u
X1 Z a_67_603# VSS VPW nfet_05v0 ad=0.3608p pd=2.52u as=0.2288p ps=1.58u w=0.82u l=0.6u
X2 VDD A2 a_255_603# VNW pfet_05v0 ad=0.38705p pd=2.08u as=0.1469p ps=1.085u w=0.565u l=0.5u
X3 VSS A2 a_67_603# VPW nfet_05v0 ad=0.2288p pd=1.58u as=93.59999f ps=0.88u w=0.36u l=0.6u
X4 Z a_67_603# VDD VNW pfet_05v0 ad=0.5368p pd=3.32u as=0.38705p ps=2.08u w=1.22u l=0.5u
X5 a_67_603# A1 VSS VPW nfet_05v0 ad=93.59999f pd=0.88u as=0.1584p ps=1.6u w=0.36u l=0.6u
.ends

.subckt gf180mcu_fd_sc_mcu7t5v0__aoi22_1$1 B1 B2 VDD VSS ZN A1 A2 VNW VPW
X0 ZN B1 a_257_69# VPW nfet_05v0 ad=0.2119p pd=1.335u as=0.1304p ps=1.135u w=0.815u l=0.6u
X1 VDD B2 a_49_472# VNW pfet_05v0 ad=0.3159p pd=1.735u as=0.5346p ps=3.31u w=1.215u l=0.5u
X2 a_49_472# B1 VDD VNW pfet_05v0 ad=0.3159p pd=1.735u as=0.3159p ps=1.735u w=1.215u l=0.5u
X3 ZN A1 a_49_472# VNW pfet_05v0 ad=0.3159p pd=1.735u as=0.3159p ps=1.735u w=1.215u l=0.5u
X4 a_49_472# A2 ZN VNW pfet_05v0 ad=0.5346p pd=3.31u as=0.3159p ps=1.735u w=1.215u l=0.5u
X5 a_257_69# B2 VSS VPW nfet_05v0 ad=0.1304p pd=1.135u as=0.3586p ps=2.51u w=0.815u l=0.6u
X6 a_665_69# A1 ZN VPW nfet_05v0 ad=0.1304p pd=1.135u as=0.2119p ps=1.335u w=0.815u l=0.6u
X7 VSS A2 a_665_69# VPW nfet_05v0 ad=0.3586p pd=2.51u as=0.1304p ps=1.135u w=0.815u l=0.6u
.ends

.subckt gf180mcu_fd_sc_mcu7t5v0__nor2_4$1 VDD VSS ZN A1 A2 VNW VPW
X0 a_1140_472# A2 VDD VNW pfet_05v0 ad=0.3172p pd=1.74u as=0.4392p ps=1.94u w=1.22u l=0.5u
X1 ZN A1 VSS VPW nfet_05v0 ad=0.1469p pd=1.085u as=0.1469p ps=1.085u w=0.565u l=0.6u
X2 ZN A1 a_1140_472# VNW pfet_05v0 ad=0.4392p pd=1.94u as=0.3172p ps=1.74u w=1.22u l=0.5u
X3 ZN A2 VSS VPW nfet_05v0 ad=0.1469p pd=1.085u as=0.2486p ps=2.01u w=0.565u l=0.6u
X4 a_1588_472# A1 ZN VNW pfet_05v0 ad=0.3172p pd=1.74u as=0.4392p ps=1.94u w=1.22u l=0.5u
X5 VDD A2 a_1588_472# VNW pfet_05v0 ad=0.5978p pd=3.42u as=0.3172p ps=1.74u w=1.22u l=0.5u
X6 ZN A1 VSS VPW nfet_05v0 ad=0.1469p pd=1.085u as=0.1469p ps=1.085u w=0.565u l=0.6u
X7 a_244_472# A2 VDD VNW pfet_05v0 ad=0.3172p pd=1.74u as=0.5978p ps=3.42u w=1.22u l=0.5u
X8 ZN A1 a_244_472# VNW pfet_05v0 ad=0.4392p pd=1.94u as=0.3172p ps=1.74u w=1.22u l=0.5u
X9 a_692_472# A1 ZN VNW pfet_05v0 ad=0.3172p pd=1.74u as=0.4392p ps=1.94u w=1.22u l=0.5u
X10 VSS A2 ZN VPW nfet_05v0 ad=0.2486p pd=2.01u as=0.1469p ps=1.085u w=0.565u l=0.6u
X11 VDD A2 a_692_472# VNW pfet_05v0 ad=0.4392p pd=1.94u as=0.3172p ps=1.74u w=1.22u l=0.5u
X12 VSS A1 ZN VPW nfet_05v0 ad=0.1469p pd=1.085u as=0.1469p ps=1.085u w=0.565u l=0.6u
X13 VSS A2 ZN VPW nfet_05v0 ad=0.1469p pd=1.085u as=0.1469p ps=1.085u w=0.565u l=0.6u
X14 VSS A1 ZN VPW nfet_05v0 ad=0.1469p pd=1.085u as=0.1469p ps=1.085u w=0.565u l=0.6u
X15 ZN A2 VSS VPW nfet_05v0 ad=0.1469p pd=1.085u as=0.1469p ps=1.085u w=0.565u l=0.6u
.ends

.subckt gf180mcu_fd_sc_mcu7t5v0__oai32_1$1 A3 B1 B2 VDD VSS ZN A1 A2 VNW VPW
X0 ZN A1 a_468_472# VNW pfet_05v0 ad=0.4392p pd=1.94u as=0.3172p ps=1.74u w=1.22u l=0.5u
X1 a_244_68# A1 VSS VPW nfet_05v0 ad=0.2132p pd=1.34u as=0.2132p ps=1.34u w=0.82u l=0.6u
X2 a_244_68# A3 VSS VPW nfet_05v0 ad=0.2132p pd=1.34u as=0.3608p ps=2.52u w=0.82u l=0.6u
X3 a_916_472# B1 ZN VNW pfet_05v0 ad=0.3172p pd=1.74u as=0.4392p ps=1.94u w=1.22u l=0.5u
X4 VDD B2 a_916_472# VNW pfet_05v0 ad=0.5368p pd=3.32u as=0.3172p ps=1.74u w=1.22u l=0.5u
X5 ZN B1 a_244_68# VPW nfet_05v0 ad=0.2132p pd=1.34u as=0.2132p ps=1.34u w=0.82u l=0.6u
X6 a_224_472# A3 VDD VNW pfet_05v0 ad=0.4392p pd=1.94u as=0.5368p ps=3.32u w=1.22u l=0.5u
X7 VSS A2 a_244_68# VPW nfet_05v0 ad=0.2132p pd=1.34u as=0.2132p ps=1.34u w=0.82u l=0.6u
X8 a_244_68# B2 ZN VPW nfet_05v0 ad=0.3608p pd=2.52u as=0.2132p ps=1.34u w=0.82u l=0.6u
X9 a_468_472# A2 a_224_472# VNW pfet_05v0 ad=0.3172p pd=1.74u as=0.4392p ps=1.94u w=1.22u l=0.5u
.ends

.subckt gf180mcu_fd_sc_mcu7t5v0__clkinv_1$1 VDD VSS I ZN VNW VPW
X0 ZN I VSS VPW nfet_05v0 ad=0.2112p pd=1.84u as=0.2112p ps=1.84u w=0.48u l=0.6u
X1 ZN I VDD VNW pfet_05v0 ad=0.5368p pd=3.32u as=0.5368p ps=3.32u w=1.22u l=0.5u
.ends

.subckt gf180mcu_fd_sc_mcu7t5v0__clkinv_4$1 VDD VSS ZN I VNW VPW
X0 ZN I VDD VNW pfet_05v0 ad=0.4392p pd=1.94u as=0.3172p ps=1.74u w=1.22u l=0.5u
X1 VSS I ZN VPW nfet_05v0 ad=0.2112p pd=1.84u as=0.1248p ps=1u w=0.48u l=0.6u
X2 ZN I VSS VPW nfet_05v0 ad=0.1248p pd=1u as=0.2112p ps=1.84u w=0.48u l=0.6u
X3 VDD I ZN VNW pfet_05v0 ad=0.5368p pd=3.32u as=0.4392p ps=1.94u w=1.22u l=0.5u
X4 ZN I VSS VPW nfet_05v0 ad=0.1248p pd=1u as=0.1248p ps=1u w=0.48u l=0.6u
X5 ZN I VDD VNW pfet_05v0 ad=0.4392p pd=1.94u as=0.5368p ps=3.32u w=1.22u l=0.5u
X6 VDD I ZN VNW pfet_05v0 ad=0.3172p pd=1.74u as=0.4392p ps=1.94u w=1.22u l=0.5u
X7 VSS I ZN VPW nfet_05v0 ad=0.1248p pd=1u as=0.1248p ps=1u w=0.48u l=0.6u
.ends

.subckt gf180mcu_fd_sc_mcu7t5v0__dffq_1$1 VDD Q CLK VSS D VNW VPW
X0 VSS CLK a_36_151# VPW nfet_05v0 ad=0.1053p pd=0.925u as=0.1782p ps=1.69u w=0.405u l=0.6u
X1 Q a_2304_115# VSS VPW nfet_05v0 ad=0.3608p pd=2.52u as=0.3608p ps=2.52u w=0.82u l=0.6u
X2 a_2304_115# a_2011_527# VSS VPW nfet_05v0 ad=0.176p pd=1.68u as=0.142p ps=1.14u w=0.4u l=0.6u
X3 a_1004_159# D a_836_159# VPW nfet_05v0 ad=0.207p pd=1.51u as=43.2f ps=0.6u w=0.36u l=0.6u
X4 a_1004_159# D a_880_527# VNW pfet_05v0 ad=0.1872p pd=1.4u as=54f ps=0.66u w=0.36u l=0.5u
X5 a_2011_527# a_36_151# a_1376_115# VNW pfet_05v0 ad=0.1665p pd=1.285u as=0.1791p ps=1.355u w=0.36u l=0.5u
X6 a_2296_527# a_448_472# a_2011_527# VNW pfet_05v0 ad=50.4f pd=0.64u as=0.1665p ps=1.285u w=0.36u l=0.5u
X7 a_1376_115# a_1004_159# VDD VNW pfet_05v0 ad=0.1791p pd=1.355u as=0.1044p ps=0.94u w=0.36u l=0.5u
X8 VDD CLK a_36_151# VNW pfet_05v0 ad=0.2249p pd=1.385u as=0.3806p ps=2.61u w=0.865u l=0.5u
X9 VSS a_1376_115# a_1328_159# VPW nfet_05v0 ad=0.2637p pd=1.825u as=43.2f ps=0.6u w=0.36u l=0.6u
X10 a_2011_527# a_448_472# a_1376_115# VPW nfet_05v0 ad=93.59999f pd=0.88u as=93.59999f ps=0.88u w=0.36u l=0.6u
X11 a_448_472# a_36_151# VDD VNW pfet_05v0 ad=0.3806p pd=2.61u as=0.2249p ps=1.385u w=0.865u l=0.5u
X12 Q a_2304_115# VDD VNW pfet_05v0 ad=0.5368p pd=3.32u as=0.5368p ps=3.32u w=1.22u l=0.5u
X13 a_1376_115# a_1004_159# VSS VPW nfet_05v0 ad=93.59999f pd=0.88u as=0.2637p ps=1.825u w=0.36u l=0.6u
X14 VSS a_2304_115# a_2256_159# VPW nfet_05v0 ad=0.142p pd=1.14u as=43.2f ps=0.6u w=0.36u l=0.6u
X15 a_836_159# a_36_151# VSS VPW nfet_05v0 ad=43.2f pd=0.6u as=0.1584p ps=1.6u w=0.36u l=0.6u
X16 a_448_472# a_36_151# VSS VPW nfet_05v0 ad=0.1782p pd=1.69u as=0.1053p ps=0.925u w=0.405u l=0.6u
X17 a_2256_159# a_36_151# a_2011_527# VPW nfet_05v0 ad=43.2f pd=0.6u as=93.59999f ps=0.88u w=0.36u l=0.6u
X18 a_880_527# a_448_472# VDD VNW pfet_05v0 ad=54f pd=0.66u as=0.4554p ps=3.25u w=0.36u l=0.5u
X19 a_1348_527# a_36_151# a_1004_159# VNW pfet_05v0 ad=43.2f pd=0.6u as=0.1872p ps=1.4u w=0.36u l=0.5u
X20 a_1328_159# a_448_472# a_1004_159# VPW nfet_05v0 ad=43.2f pd=0.6u as=0.207p ps=1.51u w=0.36u l=0.6u
X21 VDD a_1376_115# a_1348_527# VNW pfet_05v0 ad=0.1044p pd=0.94u as=43.2f ps=0.6u w=0.36u l=0.5u
X22 VDD a_2304_115# a_2296_527# VNW pfet_05v0 ad=0.23p pd=1.54u as=50.4f ps=0.64u w=0.36u l=0.5u
X23 a_2304_115# a_2011_527# VDD VNW pfet_05v0 ad=0.352p pd=2.48u as=0.23p ps=1.54u w=0.8u l=0.5u
.ends

.subckt gf180mcu_fd_sc_mcu7t5v0__aoi221_1$1 B2 C VDD VSS ZN A1 A2 B1 VNW VPW
X0 a_672_472# C a_56_472# VNW pfet_05v0 ad=0.3402p pd=1.775u as=0.37665p ps=1.835u w=1.215u l=0.5u
X1 VDD B2 a_56_472# VNW pfet_05v0 ad=0.3159p pd=1.735u as=0.5346p ps=3.31u w=1.215u l=0.5u
X2 ZN A1 a_940_90# VPW nfet_05v0 ad=0.3124p pd=2.3u as=85.2f ps=0.95u w=0.71u l=0.6u
X3 a_56_472# B1 VDD VNW pfet_05v0 ad=0.37665p pd=1.835u as=0.3159p ps=1.735u w=1.215u l=0.5u
X4 a_672_472# A1 ZN VNW pfet_05v0 ad=0.5346p pd=3.31u as=0.37665p ps=1.835u w=1.215u l=0.5u
X5 ZN A2 a_672_472# VNW pfet_05v0 ad=0.37665p pd=1.835u as=0.3402p ps=1.775u w=1.215u l=0.5u
X6 a_244_90# B2 VSS VPW nfet_05v0 ad=85.2f pd=0.95u as=0.3124p ps=2.3u w=0.71u l=0.6u
X7 ZN B1 a_244_90# VPW nfet_05v0 ad=0.21175p pd=1.41u as=85.2f ps=0.95u w=0.71u l=0.6u
X8 a_940_90# A2 VSS VPW nfet_05v0 ad=85.2f pd=0.95u as=0.22595p ps=1.45u w=0.71u l=0.6u
X9 VSS C ZN VPW nfet_05v0 ad=0.22595p pd=1.45u as=0.21175p ps=1.41u w=0.465u l=0.6u
.ends

.subckt gf180mcu_fd_sc_mcu7t5v0__dlyd_1$1 VDD I VSS Z VNW VPW
X0 a_523_68# a_47_68# VSS VPW nfet_05v0 ad=43.2f pd=0.6u as=93.59999f ps=0.88u w=0.36u l=0.6u
X1 VDD a_2763_68# a_3219_622# VNW pfet_05v0 ad=0.42p pd=2.12u as=61.19999f ps=0.7u w=0.36u l=0.5u
X2 a_1559_644# a_875_562# VDD VNW pfet_05v0 ad=61.19999f pd=0.7u as=0.1656p ps=1.28u w=0.36u l=0.5u
X3 a_671_644# a_47_68# a_523_68# VPW nfet_05v0 ad=0.369p pd=2.77u as=43.2f ps=0.6u w=0.36u l=0.6u
X4 Z a_2987_68# VSS VPW nfet_05v0 ad=0.3608p pd=2.52u as=0.21875p ps=1.52u w=0.82u l=0.6u
X5 a_503_644# a_47_68# VDD VNW pfet_05v0 ad=61.19999f pd=0.7u as=0.1116p ps=0.98u w=0.36u l=0.5u
X6 a_1107_644# a_671_644# a_875_562# VNW pfet_05v0 ad=61.19999f pd=0.7u as=0.3852p ps=2.86u w=0.36u l=0.5u
X7 a_2595_68# a_1931_562# VSS VPW nfet_05v0 ad=43.2f pd=0.6u as=93.59999f ps=0.88u w=0.36u l=0.6u
X8 a_2763_68# a_1931_562# a_2595_68# VPW nfet_05v0 ad=0.369p pd=2.77u as=43.2f ps=0.6u w=0.36u l=0.6u
X9 a_1539_68# a_875_562# VSS VPW nfet_05v0 ad=43.2f pd=0.6u as=93.59999f ps=0.88u w=0.36u l=0.6u
X10 VDD I a_47_68# VNW pfet_05v0 ad=0.1116p pd=0.98u as=0.3852p ps=2.86u w=0.36u l=0.5u
X11 a_1707_68# a_875_562# a_1539_68# VPW nfet_05v0 ad=0.369p pd=2.77u as=43.2f ps=0.6u w=0.36u l=0.6u
X12 a_2763_68# a_1931_562# a_2615_644# VNW pfet_05v0 ad=0.3852p pd=2.86u as=61.19999f ps=0.7u w=0.36u l=0.5u
X13 a_3219_622# a_2763_68# a_2987_68# VNW pfet_05v0 ad=61.19999f pd=0.7u as=0.3456p ps=2.64u w=0.36u l=0.5u
X14 a_3239_68# a_2763_68# a_2987_68# VPW nfet_05v0 ad=43.8f pd=0.605u as=0.3705p ps=2.77u w=0.365u l=0.6u
X15 a_2203_68# a_1707_68# a_1931_562# VPW nfet_05v0 ad=43.2f pd=0.6u as=0.369p ps=2.77u w=0.36u l=0.6u
X16 VSS a_1707_68# a_2203_68# VPW nfet_05v0 ad=93.59999f pd=0.88u as=43.2f ps=0.6u w=0.36u l=0.6u
X17 VDD a_1707_68# a_2163_644# VNW pfet_05v0 ad=0.1656p pd=1.28u as=61.19999f ps=0.7u w=0.36u l=0.5u
X18 VSS a_2763_68# a_3239_68# VPW nfet_05v0 ad=0.21875p pd=1.52u as=43.8f ps=0.605u w=0.365u l=0.6u
X19 a_1147_68# a_671_644# a_875_562# VPW nfet_05v0 ad=43.2f pd=0.6u as=0.369p ps=2.77u w=0.36u l=0.6u
X20 VSS a_671_644# a_1147_68# VPW nfet_05v0 ad=93.59999f pd=0.88u as=43.2f ps=0.6u w=0.36u l=0.6u
X21 Z a_2987_68# VDD VNW pfet_05v0 ad=0.5368p pd=3.32u as=0.42p ps=2.12u w=1.22u l=0.5u
X22 a_2163_644# a_1707_68# a_1931_562# VNW pfet_05v0 ad=61.19999f pd=0.7u as=0.3852p ps=2.86u w=0.36u l=0.5u
X23 a_671_644# a_47_68# a_503_644# VNW pfet_05v0 ad=0.3852p pd=2.86u as=61.19999f ps=0.7u w=0.36u l=0.5u
X24 VDD a_671_644# a_1107_644# VNW pfet_05v0 ad=0.1656p pd=1.28u as=61.19999f ps=0.7u w=0.36u l=0.5u
X25 VSS I a_47_68# VPW nfet_05v0 ad=93.59999f pd=0.88u as=0.333p ps=2.57u w=0.36u l=0.6u
X26 a_2615_644# a_1931_562# VDD VNW pfet_05v0 ad=61.19999f pd=0.7u as=0.1656p ps=1.28u w=0.36u l=0.5u
X27 a_1707_68# a_875_562# a_1559_644# VNW pfet_05v0 ad=0.3852p pd=2.86u as=61.19999f ps=0.7u w=0.36u l=0.5u
.ends

.subckt gf180mcu_fd_sc_mcu7t5v0__clkbuf_8$1 Z VSS VDD I VNW VPW
X0 Z a_224_552# VSS VPW nfet_05v0 ad=0.1118p pd=0.95u as=0.1892p ps=1.74u w=0.43u l=0.6u
X1 VSS a_224_552# Z VPW nfet_05v0 ad=0.1118p pd=0.95u as=0.1118p ps=0.95u w=0.43u l=0.6u
X2 VDD a_224_552# Z VNW pfet_05v0 ad=0.3172p pd=1.74u as=0.4392p ps=1.94u w=1.22u l=0.5u
X3 a_224_552# I VDD VNW pfet_05v0 ad=0.2952p pd=1.54u as=0.3608p ps=2.52u w=0.82u l=0.5u
X4 VDD I a_224_552# VNW pfet_05v0 ad=0.2132p pd=1.34u as=0.2952p ps=1.54u w=0.82u l=0.5u
X5 Z a_224_552# VDD VNW pfet_05v0 ad=0.4392p pd=1.94u as=0.3172p ps=1.74u w=1.22u l=0.5u
X6 VDD a_224_552# Z VNW pfet_05v0 ad=0.3172p pd=1.74u as=0.4392p ps=1.94u w=1.22u l=0.5u
X7 VSS I a_224_552# VPW nfet_05v0 ad=0.1053p pd=0.925u as=0.1053p ps=0.925u w=0.405u l=0.6u
X8 a_224_552# I VDD VNW pfet_05v0 ad=0.2952p pd=1.54u as=0.2132p ps=1.34u w=0.82u l=0.5u
X9 VDD a_224_552# Z VNW pfet_05v0 ad=0.3172p pd=1.74u as=0.4392p ps=1.94u w=1.22u l=0.5u
X10 VSS a_224_552# Z VPW nfet_05v0 ad=0.1892p pd=1.74u as=0.1118p ps=0.95u w=0.43u l=0.6u
X11 Z a_224_552# VDD VNW pfet_05v0 ad=0.4392p pd=1.94u as=0.3172p ps=1.74u w=1.22u l=0.5u
X12 Z a_224_552# VSS VPW nfet_05v0 ad=0.1118p pd=0.95u as=0.1118p ps=0.95u w=0.43u l=0.6u
X13 VSS a_224_552# Z VPW nfet_05v0 ad=0.1118p pd=0.95u as=0.1118p ps=0.95u w=0.43u l=0.6u
X14 Z a_224_552# VSS VPW nfet_05v0 ad=0.1118p pd=0.95u as=0.1118p ps=0.95u w=0.43u l=0.6u
X15 Z a_224_552# VDD VNW pfet_05v0 ad=0.4392p pd=1.94u as=0.3172p ps=1.74u w=1.22u l=0.5u
X16 VDD I a_224_552# VNW pfet_05v0 ad=0.367p pd=1.92u as=0.2952p ps=1.54u w=0.82u l=0.5u
X17 VDD a_224_552# Z VNW pfet_05v0 ad=0.5368p pd=3.32u as=0.4392p ps=1.94u w=1.22u l=0.5u
X18 a_224_552# I VSS VPW nfet_05v0 ad=0.1053p pd=0.925u as=0.1782p ps=1.69u w=0.405u l=0.6u
X19 Z a_224_552# VSS VPW nfet_05v0 ad=0.1118p pd=0.95u as=0.1118p ps=0.95u w=0.43u l=0.6u
X20 Z a_224_552# VDD VNW pfet_05v0 ad=0.4392p pd=1.94u as=0.367p ps=1.92u w=1.22u l=0.5u
X21 a_224_552# I VSS VPW nfet_05v0 ad=0.1782p pd=1.69u as=0.1053p ps=0.925u w=0.405u l=0.6u
X22 VSS a_224_552# Z VPW nfet_05v0 ad=0.1118p pd=0.95u as=0.1118p ps=0.95u w=0.43u l=0.6u
.ends

.subckt gf180mcu_fd_sc_mcu7t5v0__xnor2_1$1 VDD VSS ZN A1 A2 VNW VPW
X0 ZN a_64_93# VDD VNW pfet_05v0 ad=0.31207p pd=1.665u as=0.34437p ps=1.895u w=1.095u l=0.5u
X1 a_272_93# A2 a_64_93# VPW nfet_05v0 ad=57.59999f pd=0.68u as=0.1584p ps=1.6u w=0.36u l=0.6u
X2 VSS A1 a_272_93# VPW nfet_05v0 ad=0.218p pd=1.52u as=57.59999f ps=0.68u w=0.36u l=0.6u
X3 a_716_68# a_64_93# VSS VPW nfet_05v0 ad=0.2132p pd=1.34u as=0.218p ps=1.52u w=0.82u l=0.6u
X4 VDD A2 a_930_497# VNW pfet_05v0 ad=0.4818p pd=3.07u as=0.55297p ps=2.105u w=1.095u l=0.5u
X5 ZN A1 a_716_68# VPW nfet_05v0 ad=0.4161p pd=1.905u as=0.2132p ps=1.34u w=0.82u l=0.6u
X6 a_64_93# A2 VDD VNW pfet_05v0 ad=0.1456p pd=1.08u as=0.2464p ps=2u w=0.56u l=0.5u
X7 a_716_68# A2 ZN VPW nfet_05v0 ad=0.3608p pd=2.52u as=0.4161p ps=1.905u w=0.82u l=0.6u
X8 VDD A1 a_64_93# VNW pfet_05v0 ad=0.34437p pd=1.895u as=0.1456p ps=1.08u w=0.56u l=0.5u
X9 a_930_497# A1 ZN VNW pfet_05v0 ad=0.55297p pd=2.105u as=0.31207p ps=1.665u w=1.095u l=0.5u
.ends

.subckt gf180mcu_fd_sc_mcu7t5v0__inv_1$1 VSS ZN I VDD VNW VPW
X0 ZN I VSS VPW nfet_05v0 ad=0.3608p pd=2.52u as=0.3608p ps=2.52u w=0.82u l=0.6u
X1 ZN I VDD VNW pfet_05v0 ad=0.5368p pd=3.32u as=0.5368p ps=3.32u w=1.22u l=0.5u
.ends

.subckt gf180mcu_fd_sc_mcu7t5v0__oai22_1$1 A2 B1 B2 VDD VSS ZN A1 VNW VPW
X0 ZN A1 a_36_68# VPW nfet_05v0 ad=0.2132p pd=1.34u as=0.2132p ps=1.34u w=0.82u l=0.6u
X1 VSS B2 a_36_68# VPW nfet_05v0 ad=0.2132p pd=1.34u as=0.3608p ps=2.52u w=0.82u l=0.6u
X2 a_244_472# B2 VDD VNW pfet_05v0 ad=0.3782p pd=1.84u as=0.6588p ps=3.52u w=1.22u l=0.5u
X3 a_692_472# A1 ZN VNW pfet_05v0 ad=0.3172p pd=1.74u as=0.3782p ps=1.84u w=1.22u l=0.5u
X4 VDD A2 a_692_472# VNW pfet_05v0 ad=0.5368p pd=3.32u as=0.3172p ps=1.74u w=1.22u l=0.5u
X5 a_36_68# A2 ZN VPW nfet_05v0 ad=0.3608p pd=2.52u as=0.2132p ps=1.34u w=0.82u l=0.6u
X6 a_36_68# B1 VSS VPW nfet_05v0 ad=0.2132p pd=1.34u as=0.2132p ps=1.34u w=0.82u l=0.6u
X7 ZN B1 a_244_472# VNW pfet_05v0 ad=0.3782p pd=1.84u as=0.3782p ps=1.84u w=1.22u l=0.5u
.ends

.subckt gf180mcu_fd_sc_mcu7t5v0__xor2_1$1 VDD VSS Z A1 A2 VNW VPW
X0 a_728_472# a_56_604# VDD VNW pfet_05v0 ad=0.3172p pd=1.74u as=0.4005p ps=2.12u w=1.22u l=0.5u
X1 Z A1 a_728_472# VNW pfet_05v0 ad=0.3172p pd=1.74u as=0.3172p ps=1.74u w=1.22u l=0.5u
X2 VSS A1 a_56_604# VPW nfet_05v0 ad=0.218p pd=1.52u as=93.59999f ps=0.88u w=0.36u l=0.6u
X3 a_728_472# A2 Z VNW pfet_05v0 ad=0.5368p pd=3.32u as=0.3172p ps=1.74u w=1.22u l=0.5u
X4 Z a_56_604# VSS VPW nfet_05v0 ad=0.2132p pd=1.34u as=0.218p ps=1.52u w=0.82u l=0.6u
X5 VSS A2 a_952_68# VPW nfet_05v0 ad=0.3608p pd=2.52u as=0.1312p ps=1.14u w=0.82u l=0.6u
X6 a_244_604# A2 a_56_604# VNW pfet_05v0 ad=0.1456p pd=1.08u as=0.2464p ps=2u w=0.56u l=0.5u
X7 a_56_604# A2 VSS VPW nfet_05v0 ad=93.59999f pd=0.88u as=0.1584p ps=1.6u w=0.36u l=0.6u
X8 a_952_68# A1 Z VPW nfet_05v0 ad=0.1312p pd=1.14u as=0.2132p ps=1.34u w=0.82u l=0.6u
X9 VDD A1 a_244_604# VNW pfet_05v0 ad=0.4005p pd=2.12u as=0.1456p ps=1.08u w=0.56u l=0.5u
.ends

.subckt gf180mcu_fd_sc_mcu7t5v0__nor4_1$1 A3 A4 VDD VSS ZN A1 A2 VNW VPW
X0 a_672_472# A2 a_448_472# VNW pfet_05v0 ad=0.3782p pd=1.84u as=0.3782p ps=1.84u w=1.22u l=0.5u
X1 VSS A1 ZN VPW nfet_05v0 ad=0.1584p pd=1.6u as=93.59999f ps=0.88u w=0.36u l=0.6u
X2 VSS A3 ZN VPW nfet_05v0 ad=93.59999f pd=0.88u as=93.59999f ps=0.88u w=0.36u l=0.6u
X3 a_244_472# A4 VDD VNW pfet_05v0 ad=0.3172p pd=1.74u as=0.5368p ps=3.32u w=1.22u l=0.5u
X4 a_448_472# A3 a_244_472# VNW pfet_05v0 ad=0.3782p pd=1.84u as=0.3172p ps=1.74u w=1.22u l=0.5u
X5 ZN A2 VSS VPW nfet_05v0 ad=93.59999f pd=0.88u as=93.59999f ps=0.88u w=0.36u l=0.6u
X6 ZN A4 VSS VPW nfet_05v0 ad=93.59999f pd=0.88u as=0.1584p ps=1.6u w=0.36u l=0.6u
X7 ZN A1 a_672_472# VNW pfet_05v0 ad=0.5368p pd=3.32u as=0.3782p ps=1.84u w=1.22u l=0.5u
.ends

.subckt gf180mcu_fd_sc_mcu7t5v0__mux2_2$1 S VDD VSS Z I0 I1 VNW VPW
X0 a_1152_472# S a_124_24# VNW pfet_05v0 ad=0.1464p pd=1.46u as=0.3172p ps=1.74u w=1.22u l=0.5u
X1 a_692_68# I1 VSS VPW nfet_05v0 ad=98.39999f pd=1.06u as=0.2132p ps=1.34u w=0.82u l=0.6u
X2 a_124_24# S a_692_68# VPW nfet_05v0 ad=0.2132p pd=1.34u as=98.39999f ps=1.06u w=0.82u l=0.6u
X3 Z a_124_24# VSS VPW nfet_05v0 ad=0.2132p pd=1.34u as=0.3608p ps=2.52u w=0.82u l=0.6u
X4 a_848_380# S VSS VPW nfet_05v0 ad=0.3608p pd=2.52u as=0.2132p ps=1.34u w=0.82u l=0.6u
X5 VDD a_124_24# Z VNW pfet_05v0 ad=0.4392p pd=1.94u as=0.3477p ps=1.79u w=1.22u l=0.5u
X6 VDD I0 a_1152_472# VNW pfet_05v0 ad=0.3172p pd=1.74u as=0.1464p ps=1.46u w=1.22u l=0.5u
X7 a_692_472# I1 VDD VNW pfet_05v0 ad=0.4758p pd=2u as=0.4392p ps=1.94u w=1.22u l=0.5u
X8 a_848_380# S VDD VNW pfet_05v0 ad=0.5368p pd=3.32u as=0.3172p ps=1.74u w=1.22u l=0.5u
X9 Z a_124_24# VDD VNW pfet_05v0 ad=0.3477p pd=1.79u as=0.5368p ps=3.32u w=1.22u l=0.5u
X10 VSS I0 a_1084_68# VPW nfet_05v0 ad=0.2132p pd=1.34u as=0.1968p ps=1.3u w=0.82u l=0.6u
X11 a_1084_68# a_848_380# a_124_24# VPW nfet_05v0 ad=0.1968p pd=1.3u as=0.2132p ps=1.34u w=0.82u l=0.6u
X12 VSS a_124_24# Z VPW nfet_05v0 ad=0.2132p pd=1.34u as=0.2132p ps=1.34u w=0.82u l=0.6u
X13 a_124_24# a_848_380# a_692_472# VNW pfet_05v0 ad=0.3172p pd=1.74u as=0.4758p ps=2u w=1.22u l=0.5u
.ends

.subckt gf180mcu_fd_sc_mcu7t5v0__oai31_1$1 VDD ZN B A1 A2 VSS A3 VNW VPW
X0 a_468_497# A1 ZN VNW pfet_05v0 ad=0.58035p pd=2.155u as=0.4012p ps=1.85u w=1.095u l=0.5u
X1 a_244_69# A2 ZN VPW nfet_05v0 ad=0.2119p pd=1.335u as=0.4137p ps=1.9u w=0.815u l=0.6u
X2 a_780_497# A2 a_468_497# VNW pfet_05v0 ad=0.2847p pd=1.615u as=0.58035p ps=2.155u w=1.095u l=0.5u
X3 ZN A1 a_244_69# VPW nfet_05v0 ad=0.4137p pd=1.9u as=0.2119p ps=1.335u w=0.815u l=0.6u
X4 VDD A3 a_780_497# VNW pfet_05v0 ad=0.5913p pd=3.27u as=0.2847p ps=1.615u w=1.095u l=0.5u
X5 a_244_69# B VSS VPW nfet_05v0 ad=0.2119p pd=1.335u as=0.3586p ps=2.51u w=0.815u l=0.6u
X6 ZN B VDD VNW pfet_05v0 ad=0.4012p pd=1.85u as=0.4972p ps=3.14u w=1.13u l=0.5u
X7 ZN A3 a_244_69# VPW nfet_05v0 ad=0.3586p pd=2.51u as=0.2119p ps=1.335u w=0.815u l=0.6u
.ends

.subckt gf180mcu_fd_sc_mcu7t5v0__dlyc_1$1 Z VSS I VDD VNW VPW
X0 a_666_644# a_42_68# a_498_644# VNW pfet_05v0 ad=0.3852p pd=2.86u as=61.19999f ps=0.7u w=0.36u l=0.5u
X1 VSS I a_42_68# VPW nfet_05v0 ad=93.59999f pd=0.88u as=0.333p ps=2.57u w=0.36u l=0.6u
X2 a_1702_68# a_870_562# a_1554_644# VNW pfet_05v0 ad=0.3852p pd=2.86u as=61.19999f ps=0.7u w=0.36u l=0.5u
X3 Z a_1926_68# VDD VNW pfet_05v0 ad=0.5368p pd=3.32u as=0.379p ps=2.37u w=1.22u l=0.5u
X4 a_498_644# a_42_68# VDD VNW pfet_05v0 ad=61.19999f pd=0.7u as=0.1116p ps=0.98u w=0.36u l=0.5u
X5 a_1554_644# a_870_562# VDD VNW pfet_05v0 ad=61.19999f pd=0.7u as=0.1656p ps=1.28u w=0.36u l=0.5u
X6 a_1102_644# a_666_644# a_870_562# VNW pfet_05v0 ad=61.19999f pd=0.7u as=0.3852p ps=2.86u w=0.36u l=0.5u
X7 VDD I a_42_68# VNW pfet_05v0 ad=0.1116p pd=0.98u as=0.3852p ps=2.86u w=0.36u l=0.5u
X8 a_1534_68# a_870_562# VSS VPW nfet_05v0 ad=43.2f pd=0.6u as=93.59999f ps=0.88u w=0.36u l=0.6u
X9 a_1702_68# a_870_562# a_1534_68# VPW nfet_05v0 ad=0.369p pd=2.77u as=43.2f ps=0.6u w=0.36u l=0.6u
X10 Z a_1926_68# VSS VPW nfet_05v0 ad=0.3608p pd=2.52u as=0.28262p ps=1.87u w=0.82u l=0.6u
X11 VDD a_1702_68# a_2158_622# VNW pfet_05v0 ad=0.379p pd=2.37u as=61.19999f ps=0.7u w=0.36u l=0.5u
X12 a_518_68# a_42_68# VSS VPW nfet_05v0 ad=43.2f pd=0.6u as=93.59999f ps=0.88u w=0.36u l=0.6u
X13 a_666_644# a_42_68# a_518_68# VPW nfet_05v0 ad=0.369p pd=2.77u as=43.2f ps=0.6u w=0.36u l=0.6u
X14 a_1142_68# a_666_644# a_870_562# VPW nfet_05v0 ad=43.2f pd=0.6u as=0.369p ps=2.77u w=0.36u l=0.6u
X15 a_2158_622# a_1702_68# a_1926_68# VNW pfet_05v0 ad=61.19999f pd=0.7u as=0.3456p ps=2.64u w=0.36u l=0.5u
X16 a_2178_68# a_1702_68# a_1926_68# VPW nfet_05v0 ad=43.8f pd=0.605u as=0.3705p ps=2.77u w=0.365u l=0.6u
X17 VSS a_666_644# a_1142_68# VPW nfet_05v0 ad=93.59999f pd=0.88u as=43.2f ps=0.6u w=0.36u l=0.6u
X18 VSS a_1702_68# a_2178_68# VPW nfet_05v0 ad=0.28262p pd=1.87u as=43.8f ps=0.605u w=0.365u l=0.6u
X19 VDD a_666_644# a_1102_644# VNW pfet_05v0 ad=0.1656p pd=1.28u as=61.19999f ps=0.7u w=0.36u l=0.5u
.ends

.subckt gf180mcu_fd_sc_mcu7t5v0__nand4_1$1 A3 A4 VDD VSS ZN A1 A2 VNW VPW
X0 ZN A4 VDD VNW pfet_05v0 ad=0.2197p pd=1.365u as=0.3718p ps=2.57u w=0.845u l=0.5u
X1 VDD A3 ZN VNW pfet_05v0 ad=0.2197p pd=1.365u as=0.2197p ps=1.365u w=0.845u l=0.5u
X2 ZN A2 VDD VNW pfet_05v0 ad=0.2197p pd=1.365u as=0.2197p ps=1.365u w=0.845u l=0.5u
X3 VDD A1 ZN VNW pfet_05v0 ad=0.3718p pd=2.57u as=0.2197p ps=1.365u w=0.845u l=0.5u
X4 a_275_68# A4 VSS VPW nfet_05v0 ad=0.1517p pd=1.19u as=0.3608p ps=2.52u w=0.82u l=0.6u
X5 a_673_68# A2 a_469_68# VPW nfet_05v0 ad=0.1517p pd=1.19u as=0.1722p ps=1.24u w=0.82u l=0.6u
X6 a_469_68# A3 a_275_68# VPW nfet_05v0 ad=0.1722p pd=1.24u as=0.1517p ps=1.19u w=0.82u l=0.6u
X7 ZN A1 a_673_68# VPW nfet_05v0 ad=0.3608p pd=2.52u as=0.1517p ps=1.19u w=0.82u l=0.6u
.ends

.subckt gf180mcu_fd_sc_mcu7t5v0__nand3_4$1 A3 VDD VSS ZN A1 A2 VNW VPW
X0 VDD A1 ZN VNW pfet_05v0 ad=0.4334p pd=2.85u as=0.52205p ps=2.045u w=0.985u l=0.5u
X1 a_36_68# A1 ZN VPW nfet_05v0 ad=0.2132p pd=1.34u as=0.4161p ps=1.905u w=0.82u l=0.6u
X2 ZN A2 VDD VNW pfet_05v0 ad=0.2561p pd=1.505u as=0.30535p ps=1.605u w=0.985u l=0.5u
X3 a_36_68# A2 a_672_68# VPW nfet_05v0 ad=0.2132p pd=1.34u as=0.1722p ps=1.24u w=0.82u l=0.6u
X4 a_1732_68# A2 a_1528_68# VPW nfet_05v0 ad=0.1722p pd=1.24u as=0.1722p ps=1.24u w=0.82u l=0.6u
X5 ZN A3 VDD VNW pfet_05v0 ad=0.2561p pd=1.505u as=0.30535p ps=1.605u w=0.985u l=0.5u
X6 a_244_68# A2 a_36_68# VPW nfet_05v0 ad=0.1722p pd=1.24u as=0.3608p ps=2.52u w=0.82u l=0.6u
X7 a_1528_68# A3 VSS VPW nfet_05v0 ad=0.1722p pd=1.24u as=0.2132p ps=1.34u w=0.82u l=0.6u
X8 VDD A2 ZN VNW pfet_05v0 ad=0.2561p pd=1.505u as=0.2561p ps=1.505u w=0.985u l=0.5u
X9 ZN A1 a_36_68# VPW nfet_05v0 ad=0.4161p pd=1.905u as=0.2132p ps=1.34u w=0.82u l=0.6u
X10 VDD A3 ZN VNW pfet_05v0 ad=0.30535p pd=1.605u as=0.2561p ps=1.505u w=0.985u l=0.5u
X11 VDD A1 ZN VNW pfet_05v0 ad=0.30535p pd=1.605u as=0.52205p ps=2.045u w=0.985u l=0.5u
X12 a_1100_68# A2 a_36_68# VPW nfet_05v0 ad=0.1722p pd=1.24u as=0.2132p ps=1.34u w=0.82u l=0.6u
X13 ZN A1 VDD VNW pfet_05v0 ad=0.52205p pd=2.045u as=0.2561p ps=1.505u w=0.985u l=0.5u
X14 ZN A3 VDD VNW pfet_05v0 ad=0.2561p pd=1.505u as=0.30535p ps=1.605u w=0.985u l=0.5u
X15 ZN A1 a_1732_68# VPW nfet_05v0 ad=0.4161p pd=1.905u as=0.1722p ps=1.24u w=0.82u l=0.6u
X16 VSS A3 a_244_68# VPW nfet_05v0 ad=0.2132p pd=1.34u as=0.1722p ps=1.24u w=0.82u l=0.6u
X17 VDD A2 ZN VNW pfet_05v0 ad=0.30535p pd=1.605u as=0.2561p ps=1.505u w=0.985u l=0.5u
X18 VSS A3 a_1100_68# VPW nfet_05v0 ad=0.2132p pd=1.34u as=0.1722p ps=1.24u w=0.82u l=0.6u
X19 a_36_68# A1 ZN VPW nfet_05v0 ad=0.3608p pd=2.52u as=0.4161p ps=1.905u w=0.82u l=0.6u
X20 ZN A2 VDD VNW pfet_05v0 ad=0.2561p pd=1.505u as=0.4334p ps=2.85u w=0.985u l=0.5u
X21 a_672_68# A3 VSS VPW nfet_05v0 ad=0.1722p pd=1.24u as=0.2132p ps=1.34u w=0.82u l=0.6u
X22 VDD A3 ZN VNW pfet_05v0 ad=0.30535p pd=1.605u as=0.2561p ps=1.505u w=0.985u l=0.5u
X23 ZN A1 VDD VNW pfet_05v0 ad=0.52205p pd=2.045u as=0.30535p ps=1.605u w=0.985u l=0.5u
.ends

.subckt gf180mcu_fd_sc_mcu7t5v0__or2_2$1 VDD VSS Z A1 A2 VNW VPW
X0 Z a_56_472# VSS VPW nfet_05v0 ad=0.2132p pd=1.34u as=0.2132p ps=1.34u w=0.82u l=0.6u
X1 a_56_472# A1 VSS VPW nfet_05v0 ad=0.2132p pd=1.34u as=0.3608p ps=2.52u w=0.82u l=0.6u
X2 a_244_472# A1 a_56_472# VNW pfet_05v0 ad=0.3172p pd=1.74u as=0.5368p ps=3.32u w=1.22u l=0.5u
X3 VDD A2 a_244_472# VNW pfet_05v0 ad=0.4087p pd=1.89u as=0.3172p ps=1.74u w=1.22u l=0.5u
X4 VDD a_56_472# Z VNW pfet_05v0 ad=0.5368p pd=3.32u as=0.3477p ps=1.79u w=1.22u l=0.5u
X5 Z a_56_472# VDD VNW pfet_05v0 ad=0.3477p pd=1.79u as=0.4087p ps=1.89u w=1.22u l=0.5u
X6 VSS a_56_472# Z VPW nfet_05v0 ad=0.3608p pd=2.52u as=0.2132p ps=1.34u w=0.82u l=0.6u
X7 VSS A2 a_56_472# VPW nfet_05v0 ad=0.2132p pd=1.34u as=0.2132p ps=1.34u w=0.82u l=0.6u
.ends

.subckt gf180mcu_fd_sc_mcu7t5v0__tieh$1 Z VDD VSS VNW VPW
X0 Z a_125_24# VDD VNW pfet_05v0 ad=0.5368p pd=3.32u as=0.5368p ps=3.32u w=1.22u l=0.5u
X1 a_125_24# a_125_24# VSS VPW nfet_05v0 ad=0.3608p pd=2.52u as=0.3608p ps=2.52u w=0.82u l=0.6u
.ends

.subckt gf180mcu_fd_sc_mcu7t5v0__dlya_1$1 VSS Z I VDD VNW VPW
X0 VSS a_448_495# a_608_472# VPW nfet_05v0 ad=0.23275p pd=1.56u as=0.1584p ps=1.6u w=0.36u l=0.6u
X1 Z a_608_472# VSS VPW nfet_05v0 ad=0.3608p pd=2.52u as=0.23275p ps=1.56u w=0.82u l=0.6u
X2 a_448_495# a_36_126# VSS VPW nfet_05v0 ad=0.1584p pd=1.6u as=93.59999f ps=0.88u w=0.36u l=0.6u
X3 VDD I a_36_126# VNW pfet_05v0 ad=0.1116p pd=0.98u as=0.1584p ps=1.6u w=0.36u l=0.5u
X4 VSS I a_36_126# VPW nfet_05v0 ad=93.59999f pd=0.88u as=0.1584p ps=1.6u w=0.36u l=0.6u
X5 VDD a_448_495# a_608_472# VNW pfet_05v0 ad=0.3971p pd=2.16u as=0.1944p ps=1.8u w=0.36u l=0.5u
X6 Z a_608_472# VDD VNW pfet_05v0 ad=0.5368p pd=3.32u as=0.3971p ps=2.16u w=1.22u l=0.5u
X7 a_448_495# a_36_126# VDD VNW pfet_05v0 ad=0.1584p pd=1.6u as=0.1116p ps=0.98u w=0.36u l=0.5u
.ends

.subckt gf180mcu_fd_sc_mcu7t5v0__nor2_2$1 VDD VSS ZN A1 A2 VNW VPW
X0 a_672_472# A1 ZN VNW pfet_05v0 ad=0.4087p pd=1.89u as=0.3477p ps=1.79u w=1.22u l=0.5u
X1 ZN A1 VSS VPW nfet_05v0 ad=0.1469p pd=1.085u as=0.1469p ps=1.085u w=0.565u l=0.6u
X2 ZN A1 a_234_472# VNW pfet_05v0 ad=0.3477p pd=1.79u as=0.3782p ps=1.84u w=1.22u l=0.5u
X3 VSS A1 ZN VPW nfet_05v0 ad=0.1469p pd=1.085u as=0.1469p ps=1.085u w=0.565u l=0.6u
X4 a_234_472# A2 VDD VNW pfet_05v0 ad=0.3782p pd=1.84u as=0.5368p ps=3.32u w=1.22u l=0.5u
X5 VDD A2 a_672_472# VNW pfet_05v0 ad=0.5368p pd=3.32u as=0.4087p ps=1.89u w=1.22u l=0.5u
X6 VSS A2 ZN VPW nfet_05v0 ad=0.2486p pd=2.01u as=0.1469p ps=1.085u w=0.565u l=0.6u
X7 ZN A2 VSS VPW nfet_05v0 ad=0.1469p pd=1.085u as=0.2486p ps=2.01u w=0.565u l=0.6u
.ends

.subckt gf180mcu_fd_sc_mcu7t5v0__dffsnq_1$1 VSS CLK VDD D Q SETN VNW VPW
X0 VSS CLK a_36_151# VPW nfet_05v0 ad=0.1053p pd=0.925u as=0.1782p ps=1.69u w=0.405u l=0.6u
X1 a_1353_112# SETN a_1697_156# VPW nfet_05v0 ad=0.1989p pd=1.465u as=86.39999f ps=0.84u w=0.36u l=0.6u
X2 a_836_156# D VDD VNW pfet_05v0 ad=0.1313p pd=1.025u as=0.22725p ps=1.91u w=0.505u l=0.5u
X3 a_1040_527# a_36_151# a_836_156# VPW nfet_05v0 ad=93.59999f pd=0.88u as=93.59999f ps=0.88u w=0.36u l=0.6u
X4 a_1040_527# a_448_472# a_836_156# VNW pfet_05v0 ad=0.19315p pd=1.27u as=0.1313p ps=1.025u w=0.505u l=0.5u
X5 a_2225_156# a_36_151# a_1353_112# VNW pfet_05v0 ad=0.1079p pd=0.935u as=0.27805p ps=2.17u w=0.415u l=0.5u
X6 VSS a_1353_112# a_1284_156# VPW nfet_05v0 ad=93.59999f pd=0.88u as=62.1f ps=0.705u w=0.36u l=0.6u
X7 a_2225_156# a_448_472# a_1353_112# VPW nfet_05v0 ad=93.59999f pd=0.88u as=0.1989p ps=1.465u w=0.36u l=0.6u
X8 VDD CLK a_36_151# VNW pfet_05v0 ad=0.2249p pd=1.385u as=0.3806p ps=2.61u w=0.865u l=0.5u
X9 a_2449_156# a_448_472# a_2225_156# VNW pfet_05v0 ad=0.1826p pd=1.71u as=0.1079p ps=0.935u w=0.415u l=0.5u
X10 VDD a_3129_107# a_2449_156# VNW pfet_05v0 ad=0.3276p pd=1.62u as=0.2028p ps=1.3u w=0.78u l=0.5u
X11 Q a_3129_107# VSS VPW nfet_05v0 ad=0.3586p pd=2.51u as=0.3586p ps=2.51u w=0.815u l=0.6u
X12 a_448_472# a_36_151# VDD VNW pfet_05v0 ad=0.3806p pd=2.61u as=0.2249p ps=1.385u w=0.865u l=0.5u
X13 a_2449_156# SETN VDD VNW pfet_05v0 ad=0.2028p pd=1.3u as=0.3432p ps=2.44u w=0.78u l=0.5u
X14 VSS a_3129_107# a_3081_151# VPW nfet_05v0 ad=0.14985p pd=1.145u as=48.6f ps=0.645u w=0.405u l=0.6u
X15 a_836_156# D VSS VPW nfet_05v0 ad=93.59999f pd=0.88u as=0.1584p ps=1.6u w=0.36u l=0.6u
X16 a_448_472# a_36_151# VSS VPW nfet_05v0 ad=0.1782p pd=1.69u as=0.1053p ps=0.925u w=0.405u l=0.6u
X17 a_1353_112# a_1040_527# VDD VNW pfet_05v0 ad=0.1521p pd=1.105u as=0.3975p ps=2.185u w=0.585u l=0.5u
X18 a_3129_107# a_2225_156# VSS VPW nfet_05v0 ad=0.1782p pd=1.69u as=0.14985p ps=1.145u w=0.405u l=0.6u
X19 VDD SETN a_1353_112# VNW pfet_05v0 ad=0.4149p pd=2.65u as=0.1521p ps=1.105u w=0.585u l=0.5u
X20 a_1284_156# a_448_472# a_1040_527# VPW nfet_05v0 ad=62.1f pd=0.705u as=93.59999f ps=0.88u w=0.36u l=0.6u
X21 VDD a_1353_112# a_1293_527# VNW pfet_05v0 ad=0.3975p pd=2.185u as=0.101p ps=0.905u w=0.505u l=0.5u
X22 Q a_3129_107# VDD VNW pfet_05v0 ad=0.6561p pd=3.51u as=0.5346p ps=3.31u w=1.215u l=0.5u
X23 a_3129_107# a_2225_156# VDD VNW pfet_05v0 ad=0.3432p pd=2.44u as=0.3276p ps=1.62u w=0.78u l=0.5u
X24 a_2449_156# a_36_151# a_2225_156# VPW nfet_05v0 ad=0.2898p pd=2.33u as=93.59999f ps=0.88u w=0.36u l=0.6u
X25 a_1293_527# a_36_151# a_1040_527# VNW pfet_05v0 ad=0.101p pd=0.905u as=0.19315p ps=1.27u w=0.505u l=0.5u
X26 a_1697_156# a_1040_527# VSS VPW nfet_05v0 ad=86.39999f pd=0.84u as=93.59999f ps=0.88u w=0.36u l=0.6u
X27 a_3081_151# SETN a_2449_156# VPW nfet_05v0 ad=48.6f pd=0.645u as=0.3123p ps=2.38u w=0.405u l=0.6u
.ends

.subckt gf180mcu_fd_sc_mcu7t5v0__clkinv_20$1 VDD VSS ZN I VNW VPW
X0 ZN I VDD VNW pfet_05v0 ad=0.3782p pd=1.84u as=0.3782p ps=1.84u w=1.22u l=0.5u
X1 VDD I ZN VNW pfet_05v0 ad=0.3782p pd=1.84u as=0.3782p ps=1.84u w=1.22u l=0.5u
X2 ZN I VSS VPW nfet_05v0 ad=0.1248p pd=1u as=0.1248p ps=1u w=0.48u l=0.6u
X3 ZN I VDD VNW pfet_05v0 ad=0.3782p pd=1.84u as=0.3782p ps=1.84u w=1.22u l=0.5u
X4 ZN I VSS VPW nfet_05v0 ad=0.1248p pd=1u as=0.1248p ps=1u w=0.48u l=0.6u
X5 VSS I ZN VPW nfet_05v0 ad=0.1248p pd=1u as=0.1248p ps=1u w=0.48u l=0.6u
X6 VSS I ZN VPW nfet_05v0 ad=0.1248p pd=1u as=0.1248p ps=1u w=0.48u l=0.6u
X7 VDD I ZN VNW pfet_05v0 ad=0.3782p pd=1.84u as=0.3782p ps=1.84u w=1.22u l=0.5u
X8 ZN I VSS VPW nfet_05v0 ad=0.1248p pd=1u as=0.2112p ps=1.84u w=0.48u l=0.6u
X9 ZN I VDD VNW pfet_05v0 ad=0.3782p pd=1.84u as=0.3782p ps=1.84u w=1.22u l=0.5u
X10 ZN I VSS VPW nfet_05v0 ad=0.1248p pd=1u as=0.1248p ps=1u w=0.48u l=0.6u
X11 VSS I ZN VPW nfet_05v0 ad=0.1248p pd=1u as=0.1248p ps=1u w=0.48u l=0.6u
X12 VSS I ZN VPW nfet_05v0 ad=0.1248p pd=1u as=0.1248p ps=1u w=0.48u l=0.6u
X13 VDD I ZN VNW pfet_05v0 ad=0.3782p pd=1.84u as=0.3782p ps=1.84u w=1.22u l=0.5u
X14 ZN I VSS VPW nfet_05v0 ad=0.1248p pd=1u as=0.1248p ps=1u w=0.48u l=0.6u
X15 ZN I VSS VPW nfet_05v0 ad=0.1248p pd=1u as=0.1248p ps=1u w=0.48u l=0.6u
X16 VSS I ZN VPW nfet_05v0 ad=0.2112p pd=1.84u as=0.1248p ps=1u w=0.48u l=0.6u
X17 VDD I ZN VNW pfet_05v0 ad=0.5368p pd=3.32u as=0.3782p ps=1.84u w=1.22u l=0.5u
X18 ZN I VSS VPW nfet_05v0 ad=0.1248p pd=1u as=0.1248p ps=1u w=0.48u l=0.6u
X19 ZN I VDD VNW pfet_05v0 ad=0.3782p pd=1.84u as=0.3782p ps=1.84u w=1.22u l=0.5u
X20 VDD I ZN VNW pfet_05v0 ad=0.3782p pd=1.84u as=0.3782p ps=1.84u w=1.22u l=0.5u
X21 VDD I ZN VNW pfet_05v0 ad=0.3782p pd=1.84u as=0.3782p ps=1.84u w=1.22u l=0.5u
X22 VDD I ZN VNW pfet_05v0 ad=0.3782p pd=1.84u as=0.3782p ps=1.84u w=1.22u l=0.5u
X23 ZN I VSS VPW nfet_05v0 ad=0.1248p pd=1u as=0.1248p ps=1u w=0.48u l=0.6u
X24 ZN I VDD VNW pfet_05v0 ad=0.3782p pd=1.84u as=0.3782p ps=1.84u w=1.22u l=0.5u
X25 VSS I ZN VPW nfet_05v0 ad=0.1248p pd=1u as=0.1248p ps=1u w=0.48u l=0.6u
X26 ZN I VDD VNW pfet_05v0 ad=0.3782p pd=1.84u as=0.3782p ps=1.84u w=1.22u l=0.5u
X27 VSS I ZN VPW nfet_05v0 ad=0.1248p pd=1u as=0.1248p ps=1u w=0.48u l=0.6u
X28 VDD I ZN VNW pfet_05v0 ad=0.3782p pd=1.84u as=0.3782p ps=1.84u w=1.22u l=0.5u
X29 VDD I ZN VNW pfet_05v0 ad=0.3782p pd=1.84u as=0.3782p ps=1.84u w=1.22u l=0.5u
X30 VSS I ZN VPW nfet_05v0 ad=0.1248p pd=1u as=0.1248p ps=1u w=0.48u l=0.6u
X31 ZN I VDD VNW pfet_05v0 ad=0.3782p pd=1.84u as=0.3782p ps=1.84u w=1.22u l=0.5u
X32 ZN I VDD VNW pfet_05v0 ad=0.3782p pd=1.84u as=0.3782p ps=1.84u w=1.22u l=0.5u
X33 VSS I ZN VPW nfet_05v0 ad=0.1248p pd=1u as=0.1248p ps=1u w=0.48u l=0.6u
X34 ZN I VDD VNW pfet_05v0 ad=0.3782p pd=1.84u as=0.5368p ps=3.32u w=1.22u l=0.5u
X35 VDD I ZN VNW pfet_05v0 ad=0.3782p pd=1.84u as=0.3782p ps=1.84u w=1.22u l=0.5u
X36 VSS I ZN VPW nfet_05v0 ad=0.1248p pd=1u as=0.1248p ps=1u w=0.48u l=0.6u
X37 ZN I VSS VPW nfet_05v0 ad=0.1248p pd=1u as=0.1248p ps=1u w=0.48u l=0.6u
X38 ZN I VDD VNW pfet_05v0 ad=0.3782p pd=1.84u as=0.3782p ps=1.84u w=1.22u l=0.5u
X39 ZN I VSS VPW nfet_05v0 ad=0.1248p pd=1u as=0.1248p ps=1u w=0.48u l=0.6u
.ends

.subckt gf180mcu_fd_sc_mcu7t5v0__dffnsnq_4$1 D Q SETN VDD VSS CLKN VNW VPW
X0 a_1308_156# a_36_124# a_1044_472# VPW nfet_05v0 ad=45.6f pd=0.62u as=98.8f ps=0.9u w=0.38u l=0.6u
X1 a_2384_156# a_36_124# a_2160_156# VNW pfet_05v0 ad=0.286p pd=2.18u as=0.21025p ps=1.35u w=0.65u l=0.5u
X2 a_2384_156# SETN VDD VNW pfet_05v0 ad=0.26825p pd=1.68u as=0.3102p ps=2.29u w=0.705u l=0.5u
X3 a_1248_472# a_448_472# a_1044_472# VNW pfet_05v0 ad=72.59999f pd=0.845u as=0.1573p ps=1.125u w=0.605u l=0.5u
X4 VDD a_3148_126# a_2384_156# VNW pfet_05v0 ad=0.2427p pd=1.435u as=0.26825p ps=1.68u w=0.58u l=0.5u
X5 VDD a_1296_336# a_1248_472# VNW pfet_05v0 ad=0.38775p pd=2.135u as=72.59999f ps=0.845u w=0.605u l=0.5u
X6 a_840_156# D VSS VPW nfet_05v0 ad=0.1178p pd=1u as=0.1672p ps=1.64u w=0.38u l=0.6u
X7 a_2384_156# a_448_472# a_2160_156# VPW nfet_05v0 ad=0.1672p pd=1.64u as=98.8f ps=0.9u w=0.38u l=0.6u
X8 a_1044_472# a_448_472# a_840_156# VPW nfet_05v0 ad=98.8f pd=0.9u as=0.1178p ps=1u w=0.38u l=0.6u
X9 VDD CLKN a_36_124# VNW pfet_05v0 ad=0.2444p pd=1.46u as=0.4136p ps=2.76u w=0.94u l=0.5u
X10 a_1296_336# SETN a_1708_156# VPW nfet_05v0 ad=98.8f pd=0.9u as=0.1026p ps=0.92u w=0.38u l=0.6u
X11 a_2160_156# a_448_472# a_1296_336# VNW pfet_05v0 ad=0.21025p pd=1.35u as=0.2354p ps=1.95u w=0.535u l=0.5u
X12 a_3148_126# a_2160_156# VSS VPW nfet_05v0 ad=0.165p pd=1.63u as=0.129p ps=1.115u w=0.375u l=0.6u
X13 a_448_472# a_36_124# VDD VNW pfet_05v0 ad=0.4136p pd=2.76u as=0.2444p ps=1.46u w=0.94u l=0.5u
X14 a_448_472# a_36_124# VSS VPW nfet_05v0 ad=0.2376p pd=1.96u as=0.1404p ps=1.06u w=0.54u l=0.6u
X15 a_3148_126# a_2160_156# VDD VNW pfet_05v0 ad=0.2882p pd=2.19u as=0.2427p ps=1.435u w=0.655u l=0.5u
X16 a_3008_145# SETN a_2384_156# VPW nfet_05v0 ad=0.1335p pd=1.135u as=0.1914p ps=1.75u w=0.435u l=0.6u
X17 a_2160_156# a_36_124# a_1296_336# VPW nfet_05v0 ad=98.8f pd=0.9u as=98.8f ps=0.9u w=0.38u l=0.6u
X18 VSS a_3148_126# Q VPW nfet_05v0 ad=0.3586p pd=2.51u as=0.2119p ps=1.335u w=0.815u l=0.6u
X19 VSS a_3148_126# Q VPW nfet_05v0 ad=0.2119p pd=1.335u as=0.2119p ps=1.335u w=0.815u l=0.6u
X20 VDD a_3148_126# Q VNW pfet_05v0 ad=0.3159p pd=1.735u as=0.3159p ps=1.735u w=1.215u l=0.5u
X21 VSS a_1296_336# a_1308_156# VPW nfet_05v0 ad=0.1064p pd=0.94u as=45.6f ps=0.62u w=0.38u l=0.6u
X22 a_1708_156# a_1044_472# VSS VPW nfet_05v0 ad=0.1026p pd=0.92u as=0.1064p ps=0.94u w=0.38u l=0.6u
X23 Q a_3148_126# VSS VPW nfet_05v0 ad=0.2119p pd=1.335u as=0.3586p ps=2.51u w=0.815u l=0.6u
X24 a_840_156# D VDD VNW pfet_05v0 ad=0.1573p pd=1.125u as=0.5199p ps=3.2u w=0.605u l=0.5u
X25 VDD SETN a_1296_336# VNW pfet_05v0 ad=0.2772p pd=2.14u as=0.23515p ps=1.615u w=0.63u l=0.5u
X26 Q a_3148_126# VDD VNW pfet_05v0 ad=0.3159p pd=1.735u as=0.3159p ps=1.735u w=1.215u l=0.5u
X27 Q a_3148_126# VDD VNW pfet_05v0 ad=0.3159p pd=1.735u as=0.5346p ps=3.31u w=1.215u l=0.5u
X28 VSS a_3148_126# a_3008_145# VPW nfet_05v0 ad=0.129p pd=1.115u as=0.1335p ps=1.135u w=0.31u l=0.6u
X29 a_1296_336# a_1044_472# VDD VNW pfet_05v0 ad=0.23515p pd=1.615u as=0.38775p ps=2.135u w=0.57u l=0.5u
X30 VDD a_3148_126# Q VNW pfet_05v0 ad=0.5346p pd=3.31u as=0.3159p ps=1.735u w=1.215u l=0.5u
X31 a_1044_472# a_36_124# a_840_156# VNW pfet_05v0 ad=0.1573p pd=1.125u as=0.1573p ps=1.125u w=0.605u l=0.5u
X32 VSS CLKN a_36_124# VPW nfet_05v0 ad=0.1404p pd=1.06u as=0.2376p ps=1.96u w=0.54u l=0.6u
X33 Q a_3148_126# VSS VPW nfet_05v0 ad=0.2119p pd=1.335u as=0.2119p ps=1.335u w=0.815u l=0.6u
.ends

.subckt gf180mcu_fd_sc_mcu7t5v0__nor3_4$1 A3 VDD VSS ZN A1 A2 VNW VPW
X0 a_672_472# A3 VDD VNW pfet_05v0 ad=0.3782p pd=1.84u as=0.3782p ps=1.84u w=1.22u l=0.5u
X1 ZN A1 a_36_472# VNW pfet_05v0 ad=0.3782p pd=1.84u as=0.3782p ps=1.84u w=1.22u l=0.5u
X2 ZN A1 VSS VPW nfet_05v0 ad=0.1209p pd=0.985u as=0.1209p ps=0.985u w=0.465u l=0.6u
X3 VDD A3 a_1120_472# VNW pfet_05v0 ad=0.3782p pd=1.84u as=0.3782p ps=1.84u w=1.22u l=0.5u
X4 ZN A1 a_1792_472# VNW pfet_05v0 ad=0.3782p pd=1.84u as=0.3782p ps=1.84u w=1.22u l=0.5u
X5 VSS A2 ZN VPW nfet_05v0 ad=0.1209p pd=0.985u as=0.1209p ps=0.985u w=0.465u l=0.6u
X6 VSS A3 ZN VPW nfet_05v0 ad=0.1209p pd=0.985u as=0.1209p ps=0.985u w=0.465u l=0.6u
X7 a_1792_472# A2 a_1568_472# VNW pfet_05v0 ad=0.3782p pd=1.84u as=0.3782p ps=1.84u w=1.22u l=0.5u
X8 VSS A1 ZN VPW nfet_05v0 ad=0.1209p pd=0.985u as=0.1209p ps=0.985u w=0.465u l=0.6u
X9 VDD A3 a_224_472# VNW pfet_05v0 ad=0.3782p pd=1.84u as=0.3782p ps=1.84u w=1.22u l=0.5u
X10 VSS A2 ZN VPW nfet_05v0 ad=0.1209p pd=0.985u as=0.1209p ps=0.985u w=0.465u l=0.6u
X11 a_36_472# A1 ZN VNW pfet_05v0 ad=0.3782p pd=1.84u as=0.3782p ps=1.84u w=1.22u l=0.5u
X12 VSS A3 ZN VPW nfet_05v0 ad=0.1209p pd=0.985u as=0.1209p ps=0.985u w=0.465u l=0.6u
X13 a_1120_472# A2 a_36_472# VNW pfet_05v0 ad=0.3782p pd=1.84u as=0.3782p ps=1.84u w=1.22u l=0.5u
X14 ZN A2 VSS VPW nfet_05v0 ad=0.1209p pd=0.985u as=0.1209p ps=0.985u w=0.465u l=0.6u
X15 a_36_472# A2 a_672_472# VNW pfet_05v0 ad=0.3782p pd=1.84u as=0.3782p ps=1.84u w=1.22u l=0.5u
X16 a_36_472# A1 ZN VNW pfet_05v0 ad=0.5368p pd=3.32u as=0.3782p ps=1.84u w=1.22u l=0.5u
X17 a_1568_472# A3 VDD VNW pfet_05v0 ad=0.3782p pd=1.84u as=0.3782p ps=1.84u w=1.22u l=0.5u
X18 ZN A3 VSS VPW nfet_05v0 ad=0.1209p pd=0.985u as=0.1209p ps=0.985u w=0.465u l=0.6u
X19 VSS A1 ZN VPW nfet_05v0 ad=0.2046p pd=1.81u as=0.1209p ps=0.985u w=0.465u l=0.6u
X20 ZN A2 VSS VPW nfet_05v0 ad=0.1209p pd=0.985u as=0.2046p ps=1.81u w=0.465u l=0.6u
X21 a_224_472# A2 a_36_472# VNW pfet_05v0 ad=0.3782p pd=1.84u as=0.5368p ps=3.32u w=1.22u l=0.5u
X22 ZN A1 VSS VPW nfet_05v0 ad=0.1209p pd=0.985u as=0.1209p ps=0.985u w=0.465u l=0.6u
X23 ZN A3 VSS VPW nfet_05v0 ad=0.1209p pd=0.985u as=0.1209p ps=0.985u w=0.465u l=0.6u
.ends

.subckt gf180mcu_fd_sc_mcu7t5v0__aoi222_1$1 VSS VDD C2 C1 B2 B1 A2 A1 ZN VNW VPW
X0 a_291_68# C2 VSS VPW nfet_05v0 ad=98.39999f pd=1.06u as=0.3608p ps=2.52u w=0.82u l=0.6u
X1 a_1235_68# A2 VSS VPW nfet_05v0 ad=0.1722p pd=1.24u as=0.2132p ps=1.34u w=0.82u l=0.6u
X2 a_619_484# A1 ZN VNW pfet_05v0 ad=0.5104p pd=3.2u as=0.3596p ps=1.78u w=1.16u l=0.5u
X3 a_255_484# B1 a_619_484# VNW pfet_05v0 ad=0.3016p pd=1.68u as=0.5104p ps=3.2u w=1.16u l=0.5u
X4 a_619_484# B2 a_255_484# VNW pfet_05v0 ad=0.3016p pd=1.68u as=0.3016p ps=1.68u w=1.16u l=0.5u
X5 a_255_484# C2 VDD VNW pfet_05v0 ad=0.3016p pd=1.68u as=0.5104p ps=3.2u w=1.16u l=0.5u
X6 ZN C1 a_291_68# VPW nfet_05v0 ad=0.33825p pd=1.645u as=98.39999f ps=1.06u w=0.82u l=0.6u
X7 ZN A1 a_1235_68# VPW nfet_05v0 ad=0.3608p pd=2.52u as=0.1722p ps=1.24u w=0.82u l=0.6u
X8 VSS B2 a_744_68# VPW nfet_05v0 ad=0.2132p pd=1.34u as=0.30135p ps=1.555u w=0.82u l=0.6u
X9 VDD C1 a_255_484# VNW pfet_05v0 ad=0.5104p pd=3.2u as=0.3016p ps=1.68u w=1.16u l=0.5u
X10 ZN A2 a_619_484# VNW pfet_05v0 ad=0.3596p pd=1.78u as=0.3016p ps=1.68u w=1.16u l=0.5u
X11 a_744_68# B1 ZN VPW nfet_05v0 ad=0.30135p pd=1.555u as=0.33825p ps=1.645u w=0.82u l=0.6u
.ends

.subckt gf180mcu_fd_sc_mcu7t5v0__buf_2$1 VSS Z I VDD VNW VPW
X0 Z a_36_68# VDD VNW pfet_05v0 ad=0.3782p pd=1.84u as=0.4941p ps=2.03u w=1.22u l=0.5u
X1 VSS I a_36_68# VPW nfet_05v0 ad=0.2911p pd=1.53u as=0.3608p ps=2.52u w=0.82u l=0.6u
X2 Z a_36_68# VSS VPW nfet_05v0 ad=0.2132p pd=1.34u as=0.2911p ps=1.53u w=0.82u l=0.6u
X3 VDD I a_36_68# VNW pfet_05v0 ad=0.4941p pd=2.03u as=0.5368p ps=3.32u w=1.22u l=0.5u
X4 VSS a_36_68# Z VPW nfet_05v0 ad=0.3608p pd=2.52u as=0.2132p ps=1.34u w=0.82u l=0.6u
X5 VDD a_36_68# Z VNW pfet_05v0 ad=0.5368p pd=3.32u as=0.3782p ps=1.84u w=1.22u l=0.5u
.ends

.subckt gf180mcu_fd_sc_mcu7t5v0__buf_3$1 VSS Z I VDD VNW VPW
X0 Z a_36_68# VDD VNW pfet_05v0 ad=0.3782p pd=1.84u as=0.4941p ps=2.03u w=1.22u l=0.5u
X1 VSS I a_36_68# VPW nfet_05v0 ad=0.2911p pd=1.53u as=0.3608p ps=2.52u w=0.82u l=0.6u
X2 Z a_36_68# VDD VNW pfet_05v0 ad=0.5368p pd=3.32u as=0.3782p ps=1.84u w=1.22u l=0.5u
X3 Z a_36_68# VSS VPW nfet_05v0 ad=0.3608p pd=2.52u as=0.2132p ps=1.34u w=0.82u l=0.6u
X4 Z a_36_68# VSS VPW nfet_05v0 ad=0.2132p pd=1.34u as=0.2911p ps=1.53u w=0.82u l=0.6u
X5 VDD I a_36_68# VNW pfet_05v0 ad=0.4941p pd=2.03u as=0.5368p ps=3.32u w=1.22u l=0.5u
X6 VSS a_36_68# Z VPW nfet_05v0 ad=0.2132p pd=1.34u as=0.2132p ps=1.34u w=0.82u l=0.6u
X7 VDD a_36_68# Z VNW pfet_05v0 ad=0.3782p pd=1.84u as=0.3782p ps=1.84u w=1.22u l=0.5u
.ends

.subckt gf180mcu_fd_sc_mcu7t5v0__clkbuf_20$1 VDD VSS Z I VNW VPW
X0 Z a_224_552# VSS VPW nfet_05v0 ad=0.1222p pd=0.99u as=0.1222p ps=0.99u w=0.47u l=0.6u
X1 VSS a_224_552# Z VPW nfet_05v0 ad=0.2068p pd=1.82u as=0.1222p ps=0.99u w=0.47u l=0.6u
X2 a_224_552# I VDD VNW pfet_05v0 ad=0.2542p pd=1.44u as=0.2542p ps=1.44u w=0.82u l=0.5u
X3 Z a_224_552# VDD VNW pfet_05v0 ad=0.3782p pd=1.84u as=0.3782p ps=1.84u w=1.22u l=0.5u
X4 Z a_224_552# VSS VPW nfet_05v0 ad=0.1222p pd=0.99u as=0.1222p ps=0.99u w=0.47u l=0.6u
X5 Z a_224_552# VDD VNW pfet_05v0 ad=0.3782p pd=1.84u as=0.3782p ps=1.84u w=1.22u l=0.5u
X6 VDD a_224_552# Z VNW pfet_05v0 ad=0.3782p pd=1.84u as=0.3782p ps=1.84u w=1.22u l=0.5u
X7 VDD a_224_552# Z VNW pfet_05v0 ad=0.3782p pd=1.84u as=0.3782p ps=1.84u w=1.22u l=0.5u
X8 VSS a_224_552# Z VPW nfet_05v0 ad=0.1222p pd=0.99u as=0.1222p ps=0.99u w=0.47u l=0.6u
X9 Z a_224_552# VDD VNW pfet_05v0 ad=0.3782p pd=1.84u as=0.3782p ps=1.84u w=1.22u l=0.5u
X10 a_224_552# I VDD VNW pfet_05v0 ad=0.2542p pd=1.44u as=0.3608p ps=2.52u w=0.82u l=0.5u
X11 a_224_552# I VSS VPW nfet_05v0 ad=98.8f pd=0.9u as=98.8f ps=0.9u w=0.38u l=0.6u
X12 VDD a_224_552# Z VNW pfet_05v0 ad=0.3782p pd=1.84u as=0.3782p ps=1.84u w=1.22u l=0.5u
X13 Z a_224_552# VSS VPW nfet_05v0 ad=0.1222p pd=0.99u as=0.1222p ps=0.99u w=0.47u l=0.6u
X14 Z a_224_552# VDD VNW pfet_05v0 ad=0.4392p pd=1.94u as=0.3782p ps=1.84u w=1.22u l=0.5u
X15 Z a_224_552# VSS VPW nfet_05v0 ad=0.1222p pd=0.99u as=0.1222p ps=0.99u w=0.47u l=0.6u
X16 VDD I a_224_552# VNW pfet_05v0 ad=0.367p pd=1.92u as=0.2952p ps=1.54u w=0.82u l=0.5u
X17 VDD a_224_552# Z VNW pfet_05v0 ad=0.3782p pd=1.84u as=0.3782p ps=1.84u w=1.22u l=0.5u
X18 VSS a_224_552# Z VPW nfet_05v0 ad=0.1222p pd=0.99u as=0.1222p ps=0.99u w=0.47u l=0.6u
X19 VSS I a_224_552# VPW nfet_05v0 ad=98.8f pd=0.9u as=98.8f ps=0.9u w=0.38u l=0.6u
X20 VSS a_224_552# Z VPW nfet_05v0 ad=0.1222p pd=0.99u as=0.1222p ps=0.99u w=0.47u l=0.6u
X21 a_224_552# I VDD VNW pfet_05v0 ad=0.2542p pd=1.44u as=0.2542p ps=1.44u w=0.82u l=0.5u
X22 VDD a_224_552# Z VNW pfet_05v0 ad=0.5368p pd=3.32u as=0.4392p ps=1.94u w=1.22u l=0.5u
X23 a_224_552# I VSS VPW nfet_05v0 ad=0.1672p pd=1.64u as=98.8f ps=0.9u w=0.38u l=0.6u
X24 Z a_224_552# VSS VPW nfet_05v0 ad=0.1222p pd=0.99u as=0.1222p ps=0.99u w=0.47u l=0.6u
X25 VSS a_224_552# Z VPW nfet_05v0 ad=0.1222p pd=0.99u as=0.1222p ps=0.99u w=0.47u l=0.6u
X26 Z a_224_552# VSS VPW nfet_05v0 ad=0.1222p pd=0.99u as=0.1222p ps=0.99u w=0.47u l=0.6u
X27 VSS a_224_552# Z VPW nfet_05v0 ad=0.1222p pd=0.99u as=0.1222p ps=0.99u w=0.47u l=0.6u
X28 VDD I a_224_552# VNW pfet_05v0 ad=0.2542p pd=1.44u as=0.2542p ps=1.44u w=0.82u l=0.5u
X29 Z a_224_552# VDD VNW pfet_05v0 ad=0.3782p pd=1.84u as=0.3782p ps=1.84u w=1.22u l=0.5u
X30 VDD a_224_552# Z VNW pfet_05v0 ad=0.3782p pd=1.84u as=0.3782p ps=1.84u w=1.22u l=0.5u
X31 VSS I a_224_552# VPW nfet_05v0 ad=98.8f pd=0.9u as=98.8f ps=0.9u w=0.38u l=0.6u
X32 a_224_552# I VDD VNW pfet_05v0 ad=0.2952p pd=1.54u as=0.2542p ps=1.44u w=0.82u l=0.5u
X33 Z a_224_552# VDD VNW pfet_05v0 ad=0.3782p pd=1.84u as=0.3782p ps=1.84u w=1.22u l=0.5u
X34 VDD a_224_552# Z VNW pfet_05v0 ad=0.3782p pd=1.84u as=0.3782p ps=1.84u w=1.22u l=0.5u
X35 VDD I a_224_552# VNW pfet_05v0 ad=0.2542p pd=1.44u as=0.2542p ps=1.44u w=0.82u l=0.5u
X36 Z a_224_552# VDD VNW pfet_05v0 ad=0.3782p pd=1.84u as=0.367p ps=1.92u w=1.22u l=0.5u
X37 VSS I a_224_552# VPW nfet_05v0 ad=98.8f pd=0.9u as=0.1672p ps=1.64u w=0.38u l=0.6u
X38 Z a_224_552# VSS VPW nfet_05v0 ad=0.1222p pd=0.99u as=0.1222p ps=0.99u w=0.47u l=0.6u
X39 VSS a_224_552# Z VPW nfet_05v0 ad=0.1222p pd=0.99u as=0.1222p ps=0.99u w=0.47u l=0.6u
X40 VDD a_224_552# Z VNW pfet_05v0 ad=0.3782p pd=1.84u as=0.3782p ps=1.84u w=1.22u l=0.5u
X41 Z a_224_552# VSS VPW nfet_05v0 ad=0.1222p pd=0.99u as=0.1222p ps=0.99u w=0.47u l=0.6u
X42 a_224_552# I VSS VPW nfet_05v0 ad=98.8f pd=0.9u as=98.8f ps=0.9u w=0.38u l=0.6u
X43 VSS a_224_552# Z VPW nfet_05v0 ad=0.1222p pd=0.99u as=0.1222p ps=0.99u w=0.47u l=0.6u
X44 Z a_224_552# VDD VNW pfet_05v0 ad=0.3782p pd=1.84u as=0.3782p ps=1.84u w=1.22u l=0.5u
X45 VDD I a_224_552# VNW pfet_05v0 ad=0.2542p pd=1.44u as=0.2542p ps=1.44u w=0.82u l=0.5u
X46 VDD a_224_552# Z VNW pfet_05v0 ad=0.3782p pd=1.84u as=0.3782p ps=1.84u w=1.22u l=0.5u
X47 Z a_224_552# VSS VPW nfet_05v0 ad=0.1222p pd=0.99u as=0.2914p ps=2.18u w=0.47u l=0.6u
X48 Z a_224_552# VDD VNW pfet_05v0 ad=0.3782p pd=1.84u as=0.3782p ps=1.84u w=1.22u l=0.5u
X49 VSS I a_224_552# VPW nfet_05v0 ad=98.8f pd=0.9u as=98.8f ps=0.9u w=0.38u l=0.6u
X50 a_224_552# I VDD VNW pfet_05v0 ad=0.2542p pd=1.44u as=0.2542p ps=1.44u w=0.82u l=0.5u
X51 VSS a_224_552# Z VPW nfet_05v0 ad=0.1222p pd=0.99u as=0.1222p ps=0.99u w=0.47u l=0.6u
X52 Z a_224_552# VDD VNW pfet_05v0 ad=0.3782p pd=1.84u as=0.3782p ps=1.84u w=1.22u l=0.5u
X53 a_224_552# I VSS VPW nfet_05v0 ad=98.8f pd=0.9u as=98.8f ps=0.9u w=0.38u l=0.6u
X54 Z a_224_552# VSS VPW nfet_05v0 ad=0.1222p pd=0.99u as=0.1222p ps=0.99u w=0.47u l=0.6u
X55 VDD I a_224_552# VNW pfet_05v0 ad=0.2542p pd=1.44u as=0.2542p ps=1.44u w=0.82u l=0.5u
X56 VDD a_224_552# Z VNW pfet_05v0 ad=0.3782p pd=1.84u as=0.3782p ps=1.84u w=1.22u l=0.5u
X57 VSS a_224_552# Z VPW nfet_05v0 ad=0.1222p pd=0.99u as=0.1222p ps=0.99u w=0.47u l=0.6u
.ends

.subckt afe_dig CS CS_PD CS_PU DIN DIN_PD DIN_PU DOUT DOUT_CS DOUT_IE DOUT_OE DOUT_PD
+ DOUT_PDRV0 DOUT_PDRV1 DOUT_PU DOUT_SL RSTN RSTN_PD RSTN_PU SCLK SCLK_PD SCLK_PU
+ rst_amp_o cmp_clk[1] cmp_q[1] dac_gdn[1] dac_gn[12] dac_gn[13] dac_gn[14] dac_gn[15]
+ dac_gn[16] dac_gn[17] dac_gn[18] dac_gn[19] dac_gn[20] dac_gn[21] dac_gn[22] dac_gn[23]
+ dac_gp[12] dac_gp[13] dac_gp[14] dac_gp[15] dac_gp[16] dac_gp[17] dac_gp[18] dac_gp[19]
+ dac_gp[20] dac_gp[21] dac_gp[22] dac_gp[23] rst_sw[1] sw_ipg[1] sw_ipg_b[1] sw_rec[1]
+ sw_rec_b[1] tg_on[1] cmp_clk[0] dac_gdn[0] dac_gn[1] cmp_q[0] dac_gn[0] dac_gn[10]
+ dac_gn[11] dac_gn[2] dac_gp[1] dac_gn[3] dac_gn[4] dac_gn[5] dac_gn[6] dac_gp[2]
+ dac_gp[3] dac_gp[4] dac_gp[5] dac_gp[6] dac_gp[7] dac_gp[8] dac_gp[9] rst_sw[0]
+ dac_gn[7] sw_ipg[0] dac_gn[8] sw_ipg_b[0] dac_gn[9] sw_rec[0] dac_gp[0] sw_rec_b[0]
+ dac_gp[10] tg_on[0] dac_gp[11] dac_gp[29] cmp_q[2] dac_gp[30] dac_gp[31] dac_gp[32]
+ dac_gp[33] dac_gp[34] dac_gp[35] dac_gn[30] dac_gn[31] dac_gn[32] dac_gn[33] dac_gn[34]
+ dac_gn[35] dac_gdn[2] cmp_clk[2] dac_gn[24] rst_sw[2] dac_gn[25] dac_gn[26] sw_ipg[2]
+ dac_gn[27] dac_gn[28] sw_ipg_b[2] dac_gn[29] dac_gp[24] sw_rec[2] dac_gp[25] dac_gp[26]
+ sw_rec_b[2] dac_gp[27] dac_gp[28] tg_on[2] dac_gp[45] dac_gp[46] dac_gp[47] dac_gdn[3]
+ dac_gn[40] dac_gn[41] dac_gn[42] dac_gn[43] dac_gn[44] dac_gn[45] dac_gn[46] dac_gn[47]
+ rst_sw[3] cmp_q[3] cmp_clk[3] dac_gn[36] sw_ipg[3] dac_gn[37] dac_gn[38] dac_gp[36]
+ sw_ipg_b[3] dac_gp[37] dac_gp[38] dac_gp[39] sw_rec[3] dac_gn[39] dac_gp[40] dac_gp[41]
+ sw_rec_b[3] dac_gp[42] dac_gp[43] dac_gp[44] tg_on[3] VDD VSS
XFILLER_2_527 VDD VSS VDD VSS gf180mcu_fd_sc_mcu7t5v0__fillcap_8$1
XFILLER_2_505 VDD VSS VDD VSS gf180mcu_fd_sc_mcu7t5v0__fillcap_4$1
X_501_ VDD VSS _507_/A1 _734_/Q _532_/B VDD VSS gf180mcu_fd_sc_mcu7t5v0__nand2_1$1
X_432_ VDD VSS dac_gp[23] _747_/Q _758_/Q VDD VSS gf180mcu_fd_sc_mcu7t5v0__nand2_1$1
X_363_ _731_/Q VDD VSS _543_/A1 _729_/Q _730_/Q VDD VSS gf180mcu_fd_sc_mcu7t5v0__nor3_1$1
XFILLER_14_667 VDD VSS VDD VSS gf180mcu_fd_sc_mcu7t5v0__fillcap_64$1
XFILLER_8_170 VDD VSS VDD VSS gf180mcu_fd_sc_mcu7t5v0__fillcap_4$1
XFILLER_6_107 VDD VSS VDD VSS gf180mcu_fd_sc_mcu7t5v0__fillcap_8$1
XFILLER_12_10 VDD VSS VDD VSS gf180mcu_fd_sc_mcu7t5v0__fillcap_4$1
XFILLER_18_247 VDD VSS VDD VSS gf180mcu_fd_sc_mcu7t5v0__fillcap_64$1
X_415_ VDD VSS dac_gp[30] _761_/Q _768_/Q VDD VSS gf180mcu_fd_sc_mcu7t5v0__nand2_1$1
X_346_ VDD VSS dac_gn[2] _493_/A1 _736_/Q VDD VSS gf180mcu_fd_sc_mcu7t5v0__nor2_1$1
XFILLER_3_666 VDD VSS VDD VSS gf180mcu_fd_sc_mcu7t5v0__fillcap_32$1
XFILLER_19_534 VDD VSS VDD VSS gf180mcu_fd_sc_mcu7t5v0__fillcap_8$1
XFILLER_19_512 VDD VSS VDD VSS gf180mcu_fd_sc_mcu7t5v0__fillcap_16$1
X_329_ VDD VSS dac_gn[33] _618_/A1 _771_/Q VDD VSS gf180mcu_fd_sc_mcu7t5v0__nor2_1$1
XFILLER_9_66 VDD VSS VDD VSS gf180mcu_fd_sc_mcu7t5v0__fillcap_4$1
XFILLER_0_636 VDD VSS VDD VSS gf180mcu_fd_sc_mcu7t5v0__fillcap_8$1
XFILLER_0_614 VDD VSS VDD VSS gf180mcu_fd_sc_mcu7t5v0__fillcap_16$1
X_680_ VDD VSS _685_/B1 _782_/Q _685_/A2 VDD VSS gf180mcu_fd_sc_mcu7t5v0__nor2_1$1
XFILLER_3_485 VDD VSS VDD VSS gf180mcu_fd_sc_mcu7t5v0__fillcap_4$1
XFILLER_19_342 VDD VSS VDD VSS gf180mcu_fd_sc_mcu7t5v0__fillcap_8$1
XFILLER_0_444 VDD VSS VDD VSS gf180mcu_fd_sc_mcu7t5v0__fillcap_32$1
X_801_ _801_/D hold4/I RSTN VSS _802_/CLK VDD VDD VSS gf180mcu_fd_sc_mcu7t5v0__dffrnq_1$1
X_732_ _732_/D _732_/Q _775_/RN VSS _802_/CLK VDD VDD VSS gf180mcu_fd_sc_mcu7t5v0__dffrnq_1$1
X_663_ _663_/B _664_/B VDD VSS _776_/D _691_/A1 _663_/A2 VDD VSS gf180mcu_fd_sc_mcu7t5v0__oai211_1$1
X_594_ _594_/B _594_/C VDD VSS _753_/D _532_/B _594_/A2 VDD VSS gf180mcu_fd_sc_mcu7t5v0__aoi211_1$1
Xu_tie_DOUT_PDRV1 DOUT_PDRV1 VDD VSS VDD VSS gf180mcu_fd_sc_mcu7t5v0__tiel$1
XFILLER_15_32 VDD VSS VDD VSS gf180mcu_fd_sc_mcu7t5v0__fillcap_32$1
XFILLER_0_274 VDD VSS VDD VSS gf180mcu_fd_sc_mcu7t5v0__fillcap_4$1
X_715_ _715_/D _715_/Q RSTN VSS _802_/CLK VDD VDD VSS gf180mcu_fd_sc_mcu7t5v0__dffrnq_1$1
XFILLER_17_632 VDD VSS VDD VSS gf180mcu_fd_sc_mcu7t5v0__fillcap_64$1
X_646_ _645_/Z VDD VSS _769_/D _656_/B _646_/A2 VDD VSS gf180mcu_fd_sc_mcu7t5v0__and3_1$1
X_577_ _670_/B1 _601_/B VDD VSS _578_/A2 _772_/Q _689_/A2 _790_/Q VDD VSS gf180mcu_fd_sc_mcu7t5v0__oai221_1$1
X_500_ _558_/B VDD VSS _734_/D _500_/A1 _500_/A2 VDD VSS gf180mcu_fd_sc_mcu7t5v0__aoi21_1$1
X_431_ VDD VSS dac_gp[22] _747_/Q _759_/Q VDD VSS gf180mcu_fd_sc_mcu7t5v0__nand2_1$1
X_362_ VDD VSS _793_/D _723_/Q _794_/Q VDD VSS gf180mcu_fd_sc_mcu7t5v0__and2_1$1
X_629_ _677_/A2 VDD VSS _631_/B _765_/Q _499_/C VDD VSS gf180mcu_fd_sc_mcu7t5v0__nor3_1$1
XFILLER_10_159 VDD VSS VDD VSS gf180mcu_fd_sc_mcu7t5v0__fillcap_16$1
XFILLER_19_716 VDD VSS VDD VSS gf180mcu_fd_sc_mcu7t5v0__fillcap_16$1
X_414_ VDD VSS dac_gp[29] _761_/Q _767_/Q VDD VSS gf180mcu_fd_sc_mcu7t5v0__nand2_1$1
XFILLER_14_421 VDD VSS VDD VSS gf180mcu_fd_sc_mcu7t5v0__fillcap_8$1
X_345_ VDD VSS dac_gn[1] _493_/A1 _735_/Q VDD VSS gf180mcu_fd_sc_mcu7t5v0__nor2_1$1
XFILLER_3_612 VDD VSS VDD VSS gf180mcu_fd_sc_mcu7t5v0__fillcap_4$1
XFILLER_3_2 VDD VSS VDD VSS gf180mcu_fd_sc_mcu7t5v0__fillcap_4$1
XFILLER_2_177 VDD VSS VDD VSS gf180mcu_fd_sc_mcu7t5v0__fillcap_4$1
XFILLER_19_546 VDD VSS VDD VSS gf180mcu_fd_sc_mcu7t5v0__fillcap_8$1
X_328_ VDD VSS dac_gn[32] _618_/A1 _770_/Q VDD VSS gf180mcu_fd_sc_mcu7t5v0__nor2_1$1
XFILLER_0_648 VDD VSS VDD VSS gf180mcu_fd_sc_mcu7t5v0__fillcap_32$1
XFILLER_11_276 VDD VSS VDD VSS gf180mcu_fd_sc_mcu7t5v0__fillcap_4$1
XFILLER_19_376 VDD VSS VDD VSS gf180mcu_fd_sc_mcu7t5v0__fillcap_32$1
XFILLER_5_718 VDD VSS VDD VSS gf180mcu_fd_sc_mcu7t5v0__fillcap_8$1
X_731_ _731_/D _731_/Q _775_/RN VSS _802_/CLK VDD VDD VSS gf180mcu_fd_sc_mcu7t5v0__dffrnq_1$1
XFILLER_0_478 VDD VSS VDD VSS gf180mcu_fd_sc_mcu7t5v0__fillcap_4$1
X_662_ _663_/A2 VDD VSS _663_/B _776_/Q _662_/A2 VDD VSS gf180mcu_fd_sc_mcu7t5v0__nand3_1$1
X_800_ _800_/D hold2/I RSTN VSS _802_/CLK VDD VDD VSS gf180mcu_fd_sc_mcu7t5v0__dffrnq_1$1
X_593_ VDD _601_/B _593_/A2 _594_/C _790_/Q VSS VDD VSS gf180mcu_fd_sc_mcu7t5v0__oai21_1$1
XFILLER_3_261 VDD VSS VDD VSS gf180mcu_fd_sc_mcu7t5v0__fillcap_16$1
X_714_ _714_/D _714_/Q RSTN VSS _802_/CLK VDD VDD VSS gf180mcu_fd_sc_mcu7t5v0__dffrnq_1$1
X_645_ _689_/A3 VDD VSS _645_/Z _768_/Q _689_/A2 VDD VSS gf180mcu_fd_sc_mcu7t5v0__or3_1$1
X_576_ _669_/A3 VDD VSS _578_/A1 _748_/Q _669_/A2 VDD VSS gf180mcu_fd_sc_mcu7t5v0__nor3_1$1
X_430_ VDD VSS dac_gp[21] _747_/Q _757_/Q VDD VSS gf180mcu_fd_sc_mcu7t5v0__nand2_1$1
X_361_ VDD VSS _794_/D _723_/Q _793_/Q VDD VSS gf180mcu_fd_sc_mcu7t5v0__or2_1$2
X_628_ _628_/B _653_/B VDD VSS _764_/D _532_/B _628_/A2 VDD VSS gf180mcu_fd_sc_mcu7t5v0__aoi211_1$1
X_559_ VDD VSS _604_/C _559_/A1 _559_/A2 VDD VSS gf180mcu_fd_sc_mcu7t5v0__nor2_1$1
XFILLER_10_138 VDD VSS VDD VSS gf180mcu_fd_sc_mcu7t5v0__fillcap_4$1
XFILLER_12_89 VDD VSS VDD VSS gf180mcu_fd_sc_mcu7t5v0__fillcap_16$1
X_413_ VDD VSS dac_gp[28] _761_/Q _766_/Q VDD VSS gf180mcu_fd_sc_mcu7t5v0__nand2_1$1
X_344_ VDD VSS dac_gn[0] _493_/A1 _734_/Q VDD VSS gf180mcu_fd_sc_mcu7t5v0__nor2_1$1
XFILLER_5_120 VDD VSS VDD VSS gf180mcu_fd_sc_mcu7t5v0__fillcap_4$1
XFILLER_17_282 VDD VSS VDD VSS gf180mcu_fd_sc_mcu7t5v0__fillcap_32$1
XFILLER_2_189 VDD VSS VDD VSS gf180mcu_fd_sc_mcu7t5v0__fillcap_16$1
XFILLER_19_569 VDD VSS VDD VSS gf180mcu_fd_sc_mcu7t5v0__fillcap_4$1
X_327_ VDD VSS dac_gn[31] _618_/A1 _769_/Q VDD VSS gf180mcu_fd_sc_mcu7t5v0__nor2_1$1
XFILLER_15_572 VDD VSS VDD VSS gf180mcu_fd_sc_mcu7t5v0__fillcap_8$1
X_661_ VDD _678_/C _661_/A2 _775_/D _711_/A2 VSS VDD VSS gf180mcu_fd_sc_mcu7t5v0__oai21_1$1
X_730_ _730_/D _730_/Q _775_/RN VSS _802_/CLK VDD VDD VSS gf180mcu_fd_sc_mcu7t5v0__dffrnq_1$1
X_592_ _689_/A3 VDD VSS _594_/B _753_/Q _684_/A2 VDD VSS gf180mcu_fd_sc_mcu7t5v0__nor3_1$1
XFILLER_16_303 VDD VSS VDD VSS gf180mcu_fd_sc_mcu7t5v0__fillcap_4$1
Xu_tie_DOUT_IE DOUT_IE VDD VSS VDD VSS gf180mcu_fd_sc_mcu7t5v0__tiel$1
XFILLER_19_130 VDD VSS VDD VSS gf180mcu_fd_sc_mcu7t5v0__fillcap_4$1
X_644_ _688_/B1 _650_/A2 VDD VSS _646_/A2 _644_/A1 _689_/A3 VDD VSS gf180mcu_fd_sc_mcu7t5v0__aoi22_1$1
X_713_ _713_/D _713_/Q RSTN VSS _802_/CLK VDD VDD VSS gf180mcu_fd_sc_mcu7t5v0__dffrnq_1$1
X_575_ VDD VSS _580_/A2 _748_/Q _669_/A2 VDD VSS gf180mcu_fd_sc_mcu7t5v0__nor2_1$1
XFILLER_16_155 VDD VSS VDD VSS gf180mcu_fd_sc_mcu7t5v0__fillcap_8$1
XFILLER_8_310 VDD VSS VDD VSS gf180mcu_fd_sc_mcu7t5v0__fillcap_4$1
XFILLER_4_571 VDD VSS VDD VSS gf180mcu_fd_sc_mcu7t5v0__fillcap_16$1
X_360_ VDD VSS _775_/RN CS _360_/A2 VDD VSS gf180mcu_fd_sc_mcu7t5v0__nor2_4$1
XFILLER_13_136 VDD VSS VDD VSS gf180mcu_fd_sc_mcu7t5v0__fillcap_4$1
XFILLER_5_313 VDD VSS VDD VSS gf180mcu_fd_sc_mcu7t5v0__fillcap_16$1
X_627_ _499_/C _789_/Q _672_/B1 VDD VSS _628_/B _764_/Q _672_/A2 VDD VSS gf180mcu_fd_sc_mcu7t5v0__oai32_1$1
X_558_ _558_/B VDD VSS _743_/D _558_/A1 _558_/A2 VDD VSS gf180mcu_fd_sc_mcu7t5v0__aoi21_1$1
XFILLER_9_696 VDD VSS VDD VSS gf180mcu_fd_sc_mcu7t5v0__fillcap_4$1
X_489_ VDD VSS _558_/B _364_/Z _489_/A2 VDD VSS gf180mcu_fd_sc_mcu7t5v0__nor2_1$1
X_412_ VDD VSS dac_gp[27] _761_/Q _765_/Q VDD VSS gf180mcu_fd_sc_mcu7t5v0__nand2_1$1
X_343_ VDD VSS dac_gn[23] _343_/A1 _758_/Q VDD VSS gf180mcu_fd_sc_mcu7t5v0__nor2_1$1
XFILLER_10_640 VDD VSS VDD VSS gf180mcu_fd_sc_mcu7t5v0__fillcap_16$1
X_326_ VDD VSS dac_gn[30] _618_/A1 _768_/Q VDD VSS gf180mcu_fd_sc_mcu7t5v0__nor2_1$1
XFILLER_11_212 VDD VSS VDD VSS gf180mcu_fd_sc_mcu7t5v0__fillcap_64$1
XFILLER_15_562 VDD VSS VDD VSS gf180mcu_fd_sc_mcu7t5v0__fillcap_4$1
X_309_ VDD VSS _733_/Q _493_/A1 VDD VSS gf180mcu_fd_sc_mcu7t5v0__clkinv_1$1
Xsw\[2\].u_ipg VDD VSS sw_ipg[2] _448_/ZN VDD VSS gf180mcu_fd_sc_mcu7t5v0__clkinv_4$1
X_660_ VDD VSS _774_/D _774_/Q _660_/A2 VDD VSS gf180mcu_fd_sc_mcu7t5v0__or2_1$2
X_591_ VDD VSS _752_/D _591_/A1 _591_/A2 VDD VSS gf180mcu_fd_sc_mcu7t5v0__and2_1$1
XFILLER_19_153 VDD VSS VDD VSS gf180mcu_fd_sc_mcu7t5v0__fillcap_16$1
X_789_ VDD _789_/Q _789_/CLK VSS cmp_q[2] VDD VSS gf180mcu_fd_sc_mcu7t5v0__dffq_1$1
XFILLER_0_299 VDD VSS VDD VSS gf180mcu_fd_sc_mcu7t5v0__fillcap_4$1
X_712_ _712_/D _712_/Q RSTN VSS _802_/CLK VDD VDD VSS gf180mcu_fd_sc_mcu7t5v0__dffrnq_1$1
X_643_ VDD VSS _650_/A2 _769_/Q _691_/A2 VDD VSS gf180mcu_fd_sc_mcu7t5v0__nor2_1$1
X_574_ VDD VSS _669_/A3 _689_/A2 _670_/B1 VDD VSS gf180mcu_fd_sc_mcu7t5v0__nand2_1$1
XFILLER_16_101 VDD VSS VDD VSS gf180mcu_fd_sc_mcu7t5v0__fillcap_4$1
X_626_ VDD VSS _763_/D _626_/A1 _626_/A2 VDD VSS gf180mcu_fd_sc_mcu7t5v0__nor2_1$1
X_488_ VDD VSS _732_/D _488_/A1 _670_/B1 VDD VSS gf180mcu_fd_sc_mcu7t5v0__nand2_1$1
X_557_ _653_/B VDD VSS _558_/A2 _743_/Q _662_/A2 VDD VSS gf180mcu_fd_sc_mcu7t5v0__aoi21_1$1
XFILLER_8_130 VDD VSS VDD VSS gf180mcu_fd_sc_mcu7t5v0__fillcap_4$1
XFILLER_2_317 VDD VSS VDD VSS gf180mcu_fd_sc_mcu7t5v0__fillcap_16$1
X_342_ VDD VSS dac_gn[22] _343_/A1 _759_/Q VDD VSS gf180mcu_fd_sc_mcu7t5v0__nor2_1$1
X_411_ VDD VSS dac_gp[26] _761_/Q _764_/Q VDD VSS gf180mcu_fd_sc_mcu7t5v0__nand2_1$1
XFILLER_6_667 VDD VSS VDD VSS gf180mcu_fd_sc_mcu7t5v0__fillcap_64$1
X_609_ VDD VSS _610_/C _609_/A1 _653_/B VDD VSS gf180mcu_fd_sc_mcu7t5v0__nand2_1$1
XFILLER_11_416 VDD VSS VDD VSS gf180mcu_fd_sc_mcu7t5v0__fillcap_4$1
XFILLER_3_604 VDD VSS VDD VSS gf180mcu_fd_sc_mcu7t5v0__fillcap_8$1
X_325_ VDD VSS dac_gn[29] _618_/A1 _767_/Q VDD VSS gf180mcu_fd_sc_mcu7t5v0__nor2_1$1
XFILLER_16_519 VDD VSS VDD VSS gf180mcu_fd_sc_mcu7t5v0__fillcap_4$1
XFILLER_7_206 VDD VSS VDD VSS gf180mcu_fd_sc_mcu7t5v0__fillcap_4$1
X_308_ VDD VSS _790_/Q _609_/A1 VDD VSS gf180mcu_fd_sc_mcu7t5v0__clkinv_1$1
X_590_ _532_/B _604_/C VDD VSS _591_/A2 _609_/A1 _635_/S _590_/B1 VDD VSS gf180mcu_fd_sc_mcu7t5v0__aoi221_1$1
XFILLER_8_537 VDD VSS VDD VSS gf180mcu_fd_sc_mcu7t5v0__fillcap_4$1
X_788_ VDD _788_/Q _788_/CLK VSS cmp_q[3] VDD VSS gf180mcu_fd_sc_mcu7t5v0__dffq_1$1
XFILLER_1_702 VDD VSS VDD VSS gf180mcu_fd_sc_mcu7t5v0__fillcap_16$1
X_711_ VDD VSS dac_gn[37] _777_/Q _711_/A2 VDD VSS gf180mcu_fd_sc_mcu7t5v0__nor2_1$1
X_642_ _642_/A3 VDD VSS _768_/D _639_/Z _642_/A2 VDD VSS gf180mcu_fd_sc_mcu7t5v0__and3_1$1
X_573_ VDD VSS _747_/D _601_/B _573_/A2 VDD VSS gf180mcu_fd_sc_mcu7t5v0__nand2_1$1
XFILLER_14_639 VDD VSS VDD VSS gf180mcu_fd_sc_mcu7t5v0__fillcap_16$1
Xsw\[3\].u_rec VDD VSS sw_rec[3] _445_/ZN VDD VSS gf180mcu_fd_sc_mcu7t5v0__clkinv_4$1
X_625_ _670_/B1 _656_/B VDD VSS _626_/A2 _762_/Q _689_/A2 _789_/Q VDD VSS gf180mcu_fd_sc_mcu7t5v0__oai221_1$1
XFILLER_17_400 VDD VSS VDD VSS gf180mcu_fd_sc_mcu7t5v0__fillcap_8$1
X_487_ VDD VSS _670_/B1 _560_/A1 _616_/A2 VDD VSS gf180mcu_fd_sc_mcu7t5v0__nand2_1$1
X_556_ VDD VSS _656_/B _570_/A1 _560_/A2 VDD VSS gf180mcu_fd_sc_mcu7t5v0__nand2_1$1
XFILLER_9_621 VDD VSS VDD VSS gf180mcu_fd_sc_mcu7t5v0__fillcap_4$1
XFILLER_9_632 VDD VSS VDD VSS gf180mcu_fd_sc_mcu7t5v0__fillcap_64$1
XFILLER_17_466 VDD VSS VDD VSS gf180mcu_fd_sc_mcu7t5v0__fillcap_4$1
XFILLER_8_186 VDD VSS VDD VSS gf180mcu_fd_sc_mcu7t5v0__fillcap_16$1
Xu_adc.ckg.t\[0\].wch.g\[0\].d.u VDD u_adc.ckg.t\[0\].ug/A1 VSS u_adc.ckg.t\[0\].wch.g\[0\].d.u/Z
+ VDD VSS gf180mcu_fd_sc_mcu7t5v0__dlyd_1$1
XFILLER_12_37 VDD VSS VDD VSS gf180mcu_fd_sc_mcu7t5v0__fillcap_16$1
X_341_ VDD VSS dac_gn[21] _343_/A1 _757_/Q VDD VSS gf180mcu_fd_sc_mcu7t5v0__nor2_1$1
X_410_ VDD VSS dac_gp[25] _761_/Q _763_/Q VDD VSS gf180mcu_fd_sc_mcu7t5v0__nand2_1$1
X_608_ VDD VSS _757_/D _604_/C _608_/A2 VDD VSS gf180mcu_fd_sc_mcu7t5v0__nor2_1$1
XFILLER_17_263 VDD VSS VDD VSS gf180mcu_fd_sc_mcu7t5v0__fillcap_16$1
X_539_ VDD VSS _651_/B _689_/A2 _697_/S VDD VSS gf180mcu_fd_sc_mcu7t5v0__nand2_1$1
XFILLER_0_29 VDD VSS VDD VSS gf180mcu_fd_sc_mcu7t5v0__fillcap_4$1
X_324_ VDD VSS dac_gn[28] _618_/A1 _766_/Q VDD VSS gf180mcu_fd_sc_mcu7t5v0__nor2_1$1
XFILLER_18_550 VDD VSS VDD VSS gf180mcu_fd_sc_mcu7t5v0__fillcap_4$1
XFILLER_19_358 VDD VSS VDD VSS gf180mcu_fd_sc_mcu7t5v0__fillcap_16$1
X_307_ VDD VSS _747_/Q _343_/A1 VDD VSS gf180mcu_fd_sc_mcu7t5v0__clkinv_1$1
XFILLER_10_280 VDD VSS VDD VSS gf180mcu_fd_sc_mcu7t5v0__fillcap_4$1
XFILLER_1_72 VDD VSS VDD VSS gf180mcu_fd_sc_mcu7t5v0__fillcap_4$1
XFILLER_16_317 VDD VSS VDD VSS gf180mcu_fd_sc_mcu7t5v0__fillcap_32$1
XFILLER_19_177 VDD VSS VDD VSS gf180mcu_fd_sc_mcu7t5v0__fillcap_16$1
XFILLER_19_122 VDD VSS VDD VSS gf180mcu_fd_sc_mcu7t5v0__fillcap_8$1
X_787_ _787_/D _787_/Q RSTN VSS _802_/CLK VDD VDD VSS gf180mcu_fd_sc_mcu7t5v0__dffrnq_1$1
X_710_ VDD VSS dac_gn[47] _786_/Q _711_/A2 VDD VSS gf180mcu_fd_sc_mcu7t5v0__nor2_1$1
X_641_ _653_/B VDD VSS _642_/A3 _644_/A1 _685_/A2 VDD VSS gf180mcu_fd_sc_mcu7t5v0__aoi21_1$1
X_572_ VDD VSS _573_/A2 _747_/Q _670_/B1 VDD VSS gf180mcu_fd_sc_mcu7t5v0__nand2_1$1
Xsw\[2\].u_rec_b sw_rec_b[2] VSS VDD _449_/ZN VDD VSS gf180mcu_fd_sc_mcu7t5v0__clkbuf_8$1
X_624_ _669_/A3 VDD VSS _626_/A1 _763_/Q _669_/A2 VDD VSS gf180mcu_fd_sc_mcu7t5v0__nor3_1$1
X_555_ VDD VSS _653_/B _385_/Z _569_/A2 VDD VSS gf180mcu_fd_sc_mcu7t5v0__nor2_1$1
XFILLER_17_478 VDD VSS VDD VSS gf180mcu_fd_sc_mcu7t5v0__fillcap_4$1
X_486_ VDD VSS _731_/D _731_/Q _486_/A2 VDD VSS gf180mcu_fd_sc_mcu7t5v0__xnor2_1$1
X_340_ VDD VSS dac_gn[20] _343_/A1 _756_/Q VDD VSS gf180mcu_fd_sc_mcu7t5v0__nor2_1$1
Xu_adc.ckg.t\[1\].ug _747_/Q VDD VSS cmp_clk[1] u_adc.ckg.t\[1\].ug/A1 u_adc.ckg.t\[1\].ui/ZN
+ VDD VSS gf180mcu_fd_sc_mcu7t5v0__and3_1$1
X_538_ VDD VSS _652_/A2 _532_/B _540_/S VDD VSS gf180mcu_fd_sc_mcu7t5v0__nor2_1$1
X_607_ _695_/B _607_/C VDD VSS _608_/A2 _790_/Q _695_/A2 _757_/Q VDD VSS gf180mcu_fd_sc_mcu7t5v0__oai221_1$1
X_469_ _469_/A3 VDD VSS _660_/A2 _730_/Q _731_/Q VDD VSS gf180mcu_fd_sc_mcu7t5v0__nor3_1$1
XFILLER_5_680 VDD VSS VDD VSS gf180mcu_fd_sc_mcu7t5v0__fillcap_16$1
XFILLER_15_702 VDD VSS VDD VSS gf180mcu_fd_sc_mcu7t5v0__fillcap_16$1
X_323_ VDD VSS dac_gn[27] _618_/A1 _765_/Q VDD VSS gf180mcu_fd_sc_mcu7t5v0__nor2_1$1
XFILLER_10_451 VDD VSS VDD VSS gf180mcu_fd_sc_mcu7t5v0__fillcap_4$1
XFILLER_9_282 VDD VSS VDD VSS gf180mcu_fd_sc_mcu7t5v0__fillcap_4$1
X_306_ VDD VSS _789_/Q _644_/A1 VDD VSS gf180mcu_fd_sc_mcu7t5v0__clkinv_1$1
XFILLER_6_18 VDD VSS VDD VSS gf180mcu_fd_sc_mcu7t5v0__fillcap_16$1
X_786_ _786_/D _786_/Q RSTN VSS _802_/CLK VDD VDD VSS gf180mcu_fd_sc_mcu7t5v0__dffrnq_1$1
XFILLER_1_726 VDD VSS VDD VSS gf180mcu_fd_sc_mcu7t5v0__fillcap_4$1
X_640_ VDD VSS _642_/A2 _532_/B _640_/A2 VDD VSS gf180mcu_fd_sc_mcu7t5v0__nand2_1$1
X_571_ VDD VSS _746_/D _746_/Q _666_/A2 VDD VSS gf180mcu_fd_sc_mcu7t5v0__or2_1$2
XFILLER_8_325 VDD VSS VDD VSS gf180mcu_fd_sc_mcu7t5v0__fillcap_4$1
XFILLER_4_597 VDD VSS VDD VSS gf180mcu_fd_sc_mcu7t5v0__fillcap_4$1
X_769_ _769_/D _769_/Q RSTN VSS _802_/CLK VDD VDD VSS gf180mcu_fd_sc_mcu7t5v0__dffrnq_1$1
X_485_ VDD VSS _730_/D _730_/Q _485_/A2 VDD VSS gf180mcu_fd_sc_mcu7t5v0__xnor2_1$1
X_554_ VDD _554_/B _678_/C _558_/A1 _791_/Q VSS VDD VSS gf180mcu_fd_sc_mcu7t5v0__oai21_1$1
X_623_ VDD VSS _628_/A2 _763_/Q _669_/A2 VDD VSS gf180mcu_fd_sc_mcu7t5v0__nor2_1$1
XFILLER_8_122 VDD VSS VDD VSS gf180mcu_fd_sc_mcu7t5v0__fillcap_8$1
Xu_tie_SCLK_PU SCLK_PU VDD VSS VDD VSS gf180mcu_fd_sc_mcu7t5v0__tiel$1
XFILLER_6_648 VDD VSS VDD VSS gf180mcu_fd_sc_mcu7t5v0__fillcap_16$1
X_468_ VDD VSS _477_/A2 _730_/Q _469_/A3 VDD VSS gf180mcu_fd_sc_mcu7t5v0__nor2_1$1
X_606_ _652_/B VDD VSS _607_/C _756_/Q _689_/A2 VDD VSS gf180mcu_fd_sc_mcu7t5v0__or3_1$1
X_537_ _537_/B _537_/C VDD VSS _740_/D _532_/B _537_/A2 VDD VSS gf180mcu_fd_sc_mcu7t5v0__aoi211_1$1
X_399_ VDD VSS dac_gp[38] _778_/Q _775_/Q VDD VSS gf180mcu_fd_sc_mcu7t5v0__nand2_1$1
X_322_ VDD VSS dac_gn[26] _618_/A1 _764_/Q VDD VSS gf180mcu_fd_sc_mcu7t5v0__nor2_1$1
XFILLER_18_49 VDD VSS VDD VSS gf180mcu_fd_sc_mcu7t5v0__fillcap_4$1
XFILLER_15_500 VDD VSS VDD VSS gf180mcu_fd_sc_mcu7t5v0__fillcap_16$1
X_305_ VDD VSS _761_/Q _618_/A1 VDD VSS gf180mcu_fd_sc_mcu7t5v0__clkinv_1$1
XFILLER_19_113 VDD VSS VDD VSS gf180mcu_fd_sc_mcu7t5v0__fillcap_4$1
X_785_ _785_/D _785_/Q RSTN VSS _802_/CLK VDD VDD VSS gf180mcu_fd_sc_mcu7t5v0__dffrnq_1$1
XFILLER_7_562 VDD VSS VDD VSS gf180mcu_fd_sc_mcu7t5v0__fillcap_4$1
X_570_ VDD VSS _664_/B _570_/A1 _616_/A2 VDD VSS gf180mcu_fd_sc_mcu7t5v0__nand2_1$1
X_768_ _768_/D _768_/Q RSTN VSS _802_/CLK VDD VDD VSS gf180mcu_fd_sc_mcu7t5v0__dffrnq_1$1
X_699_ _695_/B _699_/B1 _685_/C VDD VSS _787_/D _699_/A1 _692_/B VDD VSS gf180mcu_fd_sc_mcu7t5v0__oai32_1$1
X_622_ _622_/B _653_/B VDD VSS _762_/D _622_/A1 _622_/A2 VDD VSS gf180mcu_fd_sc_mcu7t5v0__aoi211_1$1
X_484_ _484_/A3 VDD VSS _486_/A2 _729_/Q _730_/Q VDD VSS gf180mcu_fd_sc_mcu7t5v0__nand3_1$1
X_553_ VDD _678_/C _689_/A2 _554_/B _553_/A1 VSS VDD VSS gf180mcu_fd_sc_mcu7t5v0__oai21_1$1
XFILLER_12_18 VDD VSS VDD VSS gf180mcu_fd_sc_mcu7t5v0__fillcap_16$1
Xu_adc.ckg.t\[1\].ui VSS u_adc.ckg.t\[1\].ui/ZN _790_/CLK VDD VDD VSS gf180mcu_fd_sc_mcu7t5v0__inv_1$1
XFILLER_10_656 VDD VSS VDD VSS gf180mcu_fd_sc_mcu7t5v0__fillcap_8$1
XFILLER_10_667 VDD VSS VDD VSS gf180mcu_fd_sc_mcu7t5v0__fillcap_64$1
X_605_ VDD VSS _756_/D _603_/Z _605_/A2 VDD VSS gf180mcu_fd_sc_mcu7t5v0__and2_1$1
X_398_ VDD VSS dac_gp[37] _777_/Q _775_/Q VDD VSS gf180mcu_fd_sc_mcu7t5v0__nand2_1$1
X_467_ _467_/A3 VDD VSS _469_/A3 _729_/Q _543_/A3 VDD VSS gf180mcu_fd_sc_mcu7t5v0__nand3_1$1
X_536_ VDD _567_/C _649_/A2 _537_/C _791_/Q VSS VDD VSS gf180mcu_fd_sc_mcu7t5v0__oai21_1$1
X_321_ VDD VSS dac_gn[25] _618_/A1 _763_/Q VDD VSS gf180mcu_fd_sc_mcu7t5v0__nor2_1$1
XFILLER_15_726 VDD VSS VDD VSS gf180mcu_fd_sc_mcu7t5v0__fillcap_4$1
XFILLER_13_61 VDD VSS VDD VSS gf180mcu_fd_sc_mcu7t5v0__fillcap_8$1
XFILLER_13_72 VDD VSS VDD VSS gf180mcu_fd_sc_mcu7t5v0__fillcap_64$1
XFILLER_18_597 VDD VSS VDD VSS gf180mcu_fd_sc_mcu7t5v0__fillcap_64$1
XFILLER_9_273 VDD VSS VDD VSS gf180mcu_fd_sc_mcu7t5v0__fillcap_4$1
X_519_ _519_/B VDD VSS _737_/D _683_/A1 _523_/B1 VDD VSS gf180mcu_fd_sc_mcu7t5v0__aoi21_1$1
XFILLER_11_206 VDD VSS VDD VSS gf180mcu_fd_sc_mcu7t5v0__fillcap_4$1
X_304_ VDD VSS _788_/Q _691_/A1 VDD VSS gf180mcu_fd_sc_mcu7t5v0__clkinv_1$1
Xsw\[3\].u_ipg_b sw_ipg_b[3] VSS VDD _447_/ZN VDD VSS gf180mcu_fd_sc_mcu7t5v0__clkbuf_8$1
X_784_ _784_/D _784_/Q RSTN VSS _802_/CLK VDD VDD VSS gf180mcu_fd_sc_mcu7t5v0__dffrnq_1$1
XFILLER_19_93 VDD VSS VDD VSS gf180mcu_fd_sc_mcu7t5v0__fillcap_4$1
XFILLER_16_139 VDD VSS VDD VSS gf180mcu_fd_sc_mcu7t5v0__fillcap_16$1
X_767_ _767_/D _767_/Q RSTN VSS _802_/CLK VDD VDD VSS gf180mcu_fd_sc_mcu7t5v0__dffrnq_1$1
X_698_ _695_/B _697_/Z _652_/B VDD VSS _699_/B1 _692_/B VDD VSS gf180mcu_fd_sc_mcu7t5v0__oai22_1$1
XFILLER_15_150 VDD VSS VDD VSS gf180mcu_fd_sc_mcu7t5v0__fillcap_4$1
X_621_ _669_/A3 VDD VSS _622_/B _762_/Q _666_/A2 VDD VSS gf180mcu_fd_sc_mcu7t5v0__nor3_1$1
X_483_ VDD VSS _729_/D _729_/Q _484_/A3 VDD VSS gf180mcu_fd_sc_mcu7t5v0__xor2_1$1
XFILLER_12_131 VDD VSS VDD VSS gf180mcu_fd_sc_mcu7t5v0__fillcap_4$1
X_552_ VDD VSS _742_/D _558_/B _552_/A2 VDD VSS gf180mcu_fd_sc_mcu7t5v0__nor2_1$1
X_535_ _691_/A2 _540_/S VDD VSS _537_/B _740_/Q _532_/B VDD VSS gf180mcu_fd_sc_mcu7t5v0__nor4_1$1
X_604_ _532_/B _604_/C VDD VSS _605_/A2 _609_/A1 _692_/B _604_/B1 VDD VSS gf180mcu_fd_sc_mcu7t5v0__aoi221_1$1
X_397_ VDD VSS dac_gp[36] _776_/Q _775_/Q VDD VSS gf180mcu_fd_sc_mcu7t5v0__nand2_1$1
X_466_ _466_/S VDD VSS _718_/D _718_/Q _717_/Q VDD VSS gf180mcu_fd_sc_mcu7t5v0__mux2_2$1
X_320_ VDD VSS dac_gn[24] _618_/A1 _762_/Q VDD VSS gf180mcu_fd_sc_mcu7t5v0__nor2_1$1
X_518_ VDD _519_/B _518_/B _736_/Q _689_/A2 VSS _635_/S VDD VSS gf180mcu_fd_sc_mcu7t5v0__oai31_1$1
X_449_ VDD VSS _449_/ZN _793_/Q _797_/Q VDD VSS gf180mcu_fd_sc_mcu7t5v0__nand2_1$1
XFILLER_3_406 VDD VSS VDD VSS gf180mcu_fd_sc_mcu7t5v0__fillcap_4$1
X_303_ VDD VSS _787_/Q _699_/A1 VDD VSS gf180mcu_fd_sc_mcu7t5v0__clkinv_1$1
XFILLER_18_395 VDD VSS VDD VSS gf180mcu_fd_sc_mcu7t5v0__fillcap_4$1
XFILLER_19_104 VDD VSS VDD VSS gf180mcu_fd_sc_mcu7t5v0__fillcap_4$1
X_783_ _783_/D _783_/Q RSTN VSS _802_/CLK VDD VDD VSS gf180mcu_fd_sc_mcu7t5v0__dffrnq_1$1
XFILLER_19_682 VDD VSS VDD VSS gf180mcu_fd_sc_mcu7t5v0__fillcap_32$1
XFILLER_1_718 VDD VSS VDD VSS gf180mcu_fd_sc_mcu7t5v0__fillcap_8$1
XFILLER_0_206 VDD VSS VDD VSS gf180mcu_fd_sc_mcu7t5v0__fillcap_32$1
XFILLER_16_107 VDD VSS VDD VSS gf180mcu_fd_sc_mcu7t5v0__fillcap_32$1
XFILLER_8_317 VDD VSS VDD VSS gf180mcu_fd_sc_mcu7t5v0__fillcap_8$1
X_766_ _766_/D _766_/Q RSTN VSS _802_/CLK VDD VDD VSS gf180mcu_fd_sc_mcu7t5v0__dffrnq_1$1
X_697_ _697_/S VDD VSS _697_/Z _788_/Q _785_/Q VDD VSS gf180mcu_fd_sc_mcu7t5v0__mux2_2$1
XFILLER_7_97 VDD VSS VDD VSS gf180mcu_fd_sc_mcu7t5v0__fillcap_8$1
X_620_ VDD VSS _622_/A2 _789_/Q _666_/A2 VDD VSS gf180mcu_fd_sc_mcu7t5v0__nand2_1$1
X_551_ _695_/B _551_/C VDD VSS _552_/A2 _791_/Q _695_/A2 _742_/Q VDD VSS gf180mcu_fd_sc_mcu7t5v0__oai221_1$1
X_482_ VDD VSS _485_/A2 _729_/Q _484_/A3 VDD VSS gf180mcu_fd_sc_mcu7t5v0__nand2_1$1
XFILLER_13_666 VDD VSS VDD VSS gf180mcu_fd_sc_mcu7t5v0__fillcap_32$1
X_749_ _749_/D _749_/Q RSTN VSS _802_/CLK VDD VDD VSS gf180mcu_fd_sc_mcu7t5v0__dffrnq_1$1
X_534_ _560_/A1 VDD VSS _697_/S _543_/A1 _687_/A1 VDD VSS gf180mcu_fd_sc_mcu7t5v0__nand3_1$1
X_465_ _466_/S VDD VSS _717_/D _717_/Q _716_/Q VDD VSS gf180mcu_fd_sc_mcu7t5v0__mux2_2$1
X_603_ _652_/B VDD VSS _603_/Z _756_/Q _651_/B VDD VSS gf180mcu_fd_sc_mcu7t5v0__or3_1$1
X_396_ _396_/B _396_/C VDD VSS _792_/D _364_/Z _396_/A2 VDD VSS gf180mcu_fd_sc_mcu7t5v0__oai211_1$1
XFILLER_13_474 VDD VSS VDD VSS gf180mcu_fd_sc_mcu7t5v0__fillcap_16$1
XFILLER_4_10 VDD VSS VDD VSS gf180mcu_fd_sc_mcu7t5v0__fillcap_4$1
XFILLER_1_131 VDD VSS VDD VSS gf180mcu_fd_sc_mcu7t5v0__fillcap_4$1
X_448_ VDD VSS _448_/ZN _797_/Q _452_/A2 VDD VSS gf180mcu_fd_sc_mcu7t5v0__nand2_1$1
X_517_ _558_/B VDD VSS _518_/B _529_/A1 _635_/S VDD VSS gf180mcu_fd_sc_mcu7t5v0__aoi21_1$1
X_379_ VDD VSS _379_/Z _726_/Q _725_/Q VDD VSS gf180mcu_fd_sc_mcu7t5v0__and2_1$1
XFILLER_9_253 VDD VSS VDD VSS gf180mcu_fd_sc_mcu7t5v0__fillcap_4$1
Xu_adc.ckg.t\[1\].wch.g\[1\].genblk1.c.u _790_/CLK VSS u_adc.ckg.t\[1\].wch.g\[0\].d.u/Z
+ VDD VDD VSS gf180mcu_fd_sc_mcu7t5v0__dlyc_1$1
XFILLER_19_308 VDD VSS VDD VSS gf180mcu_fd_sc_mcu7t5v0__fillcap_32$1
X_302_ VDD VSS _727_/Q _542_/A2 VDD VSS gf180mcu_fd_sc_mcu7t5v0__clkinv_1$1
XFILLER_7_702 VDD VSS VDD VSS gf180mcu_fd_sc_mcu7t5v0__fillcap_16$1
XFILLER_10_241 VDD VSS VDD VSS gf180mcu_fd_sc_mcu7t5v0__fillcap_4$1
XFILLER_1_99 VDD VSS VDD VSS gf180mcu_fd_sc_mcu7t5v0__fillcap_32$1
XFILLER_19_138 VDD VSS VDD VSS gf180mcu_fd_sc_mcu7t5v0__fillcap_8$1
X_782_ _782_/D _782_/Q RSTN VSS _802_/CLK VDD VDD VSS gf180mcu_fd_sc_mcu7t5v0__dffrnq_1$1
XFILLER_15_333 VDD VSS VDD VSS gf180mcu_fd_sc_mcu7t5v0__fillcap_4$1
XFILLER_7_554 VDD VSS VDD VSS gf180mcu_fd_sc_mcu7t5v0__fillcap_4$1
XFILLER_11_572 VDD VSS VDD VSS gf180mcu_fd_sc_mcu7t5v0__fillcap_4$1
X_765_ _765_/D _765_/Q RSTN VSS _802_/CLK VDD VDD VSS gf180mcu_fd_sc_mcu7t5v0__dffrnq_1$1
X_696_ VDD _696_/B _695_/B _786_/D _696_/A1 VSS VDD VSS gf180mcu_fd_sc_mcu7t5v0__oai21_1$1
XFILLER_19_491 VDD VSS VDD VSS gf180mcu_fd_sc_mcu7t5v0__fillcap_4$1
X_481_ VDD VSS _484_/A3 _481_/A1 _481_/A2 VDD VSS gf180mcu_fd_sc_mcu7t5v0__nor2_1$1
X_550_ VDD VSS _551_/C _532_/B _550_/A2 VDD VSS gf180mcu_fd_sc_mcu7t5v0__nand2_1$1
XFILLER_12_177 VDD VSS VDD VSS gf180mcu_fd_sc_mcu7t5v0__fillcap_8$1
X_679_ VDD VSS _781_/D _679_/A1 _679_/A2 VDD VSS gf180mcu_fd_sc_mcu7t5v0__nor2_1$1
X_748_ _748_/D _748_/Q RSTN VSS _802_/CLK VDD VDD VSS gf180mcu_fd_sc_mcu7t5v0__dffrnq_1$1
X_602_ _602_/B _602_/C VDD VSS _755_/D _532_/B _602_/A2 VDD VSS gf180mcu_fd_sc_mcu7t5v0__aoi211_1$1
X_464_ _466_/S VDD VSS _716_/D _716_/Q _715_/Q VDD VSS gf180mcu_fd_sc_mcu7t5v0__mux2_2$1
X_533_ _559_/A1 VDD VSS _540_/S _364_/Z _533_/A2 VDD VSS gf180mcu_fd_sc_mcu7t5v0__nor3_1$1
X_395_ VDD VSS _396_/C _744_/Q _532_/B VDD VSS gf180mcu_fd_sc_mcu7t5v0__nand2_1$1
XFILLER_5_696 VDD VSS VDD VSS gf180mcu_fd_sc_mcu7t5v0__fillcap_4$1
XFILLER_15_718 VDD VSS VDD VSS gf180mcu_fd_sc_mcu7t5v0__fillcap_8$1
XFILLER_8_2 VDD VSS VDD VSS gf180mcu_fd_sc_mcu7t5v0__fillcap_8$1
X_447_ VDD VSS _447_/ZN _798_/Q _452_/A2 VDD VSS gf180mcu_fd_sc_mcu7t5v0__nand2_1$1
X_378_ _378_/A3 _378_/A4 VDD VSS _387_/C _378_/A1 _378_/A2 VDD VSS gf180mcu_fd_sc_mcu7t5v0__nand4_1$1
X_516_ VDD VSS _523_/B1 _737_/Q _685_/A2 VDD VSS gf180mcu_fd_sc_mcu7t5v0__nor2_1$1
XFILLER_9_265 VDD VSS VDD VSS gf180mcu_fd_sc_mcu7t5v0__fillcap_8$1
X_301_ VDD VSS _728_/Q _481_/A1 VDD VSS gf180mcu_fd_sc_mcu7t5v0__clkinv_1$1
XFILLER_6_279 VDD VSS VDD VSS gf180mcu_fd_sc_mcu7t5v0__fillcap_4$1
XFILLER_10_264 VDD VSS VDD VSS gf180mcu_fd_sc_mcu7t5v0__fillcap_16$1
XFILLER_2_441 VDD VSS VDD VSS gf180mcu_fd_sc_mcu7t5v0__fillcap_8$1
Xu_tie_DOUT_PU DOUT_PU VDD VSS VDD VSS gf180mcu_fd_sc_mcu7t5v0__tiel$1
X_781_ _781_/D _781_/Q RSTN VSS _802_/CLK VDD VDD VSS gf180mcu_fd_sc_mcu7t5v0__dffrnq_1$1
XFILLER_19_52 VDD VSS VDD VSS gf180mcu_fd_sc_mcu7t5v0__fillcap_8$1
X_764_ _764_/D _764_/Q RSTN VSS _802_/CLK VDD VDD VSS gf180mcu_fd_sc_mcu7t5v0__dffrnq_1$1
X_695_ _695_/B _695_/C VDD VSS _696_/B _788_/Q _695_/A2 VDD VSS gf180mcu_fd_sc_mcu7t5v0__oai211_1$1
XFILLER_15_142 VDD VSS VDD VSS gf180mcu_fd_sc_mcu7t5v0__fillcap_8$1
XFILLER_7_66 VDD VSS VDD VSS gf180mcu_fd_sc_mcu7t5v0__fillcap_4$1
X_480_ VDD VSS _728_/D _481_/A1 _481_/A2 VDD VSS gf180mcu_fd_sc_mcu7t5v0__xor2_1$1
XFILLER_16_31 VDD VSS VDD VSS gf180mcu_fd_sc_mcu7t5v0__fillcap_4$1
XFILLER_12_123 VDD VSS VDD VSS gf180mcu_fd_sc_mcu7t5v0__fillcap_8$1
XFILLER_4_333 VDD VSS VDD VSS gf180mcu_fd_sc_mcu7t5v0__fillcap_4$1
X_747_ _747_/D _747_/Q _775_/RN VSS _802_/CLK VDD VDD VSS gf180mcu_fd_sc_mcu7t5v0__dffrnq_1$1
X_678_ _678_/B1 _678_/C VDD VSS _679_/A2 _780_/Q _689_/A2 _788_/Q VDD VSS gf180mcu_fd_sc_mcu7t5v0__oai221_1$1
XFILLER_16_473 VDD VSS VDD VSS gf180mcu_fd_sc_mcu7t5v0__fillcap_4$1
X_601_ VDD _601_/B _649_/A2 _602_/C _790_/Q VSS VDD VSS gf180mcu_fd_sc_mcu7t5v0__oai21_1$1
X_463_ _466_/S VDD VSS _715_/D _715_/Q _714_/Q VDD VSS gf180mcu_fd_sc_mcu7t5v0__mux2_2$1
X_394_ _394_/A3 VDD VSS _689_/A2 _364_/Z _385_/Z VDD VSS gf180mcu_fd_sc_mcu7t5v0__nand3_4$1
X_532_ _532_/B VDD VSS _691_/B _687_/A1 _687_/A2 VDD VSS gf180mcu_fd_sc_mcu7t5v0__aoi21_1$1
XFILLER_10_402 VDD VSS VDD VSS gf180mcu_fd_sc_mcu7t5v0__fillcap_4$1
XFILLER_13_10 VDD VSS VDD VSS gf180mcu_fd_sc_mcu7t5v0__fillcap_4$1
XFILLER_2_667 VDD VSS VDD VSS gf180mcu_fd_sc_mcu7t5v0__fillcap_64$1
X_515_ _543_/A3 VDD VSS _593_/A2 _543_/A1 _515_/A2 VDD VSS gf180mcu_fd_sc_mcu7t5v0__nand3_1$1
X_446_ VDD VSS _452_/A2 _793_/Q _794_/Q VDD VSS gf180mcu_fd_sc_mcu7t5v0__nor2_1$1
X_377_ _570_/A1 VDD VSS _378_/A4 _802_/D _687_/A1 VDD VSS gf180mcu_fd_sc_mcu7t5v0__nand3_1$1
XFILLER_13_273 VDD VSS VDD VSS gf180mcu_fd_sc_mcu7t5v0__fillcap_4$1
XFILLER_15_516 VDD VSS VDD VSS gf180mcu_fd_sc_mcu7t5v0__fillcap_4$1
X_300_ VDD VSS _725_/Q _503_/A2 VDD VSS gf180mcu_fd_sc_mcu7t5v0__clkinv_1$1
XFILLER_6_247 VDD VSS VDD VSS gf180mcu_fd_sc_mcu7t5v0__fillcap_32$1
XFILLER_7_726 VDD VSS VDD VSS gf180mcu_fd_sc_mcu7t5v0__fillcap_4$1
XFILLER_2_497 VDD VSS VDD VSS gf180mcu_fd_sc_mcu7t5v0__fillcap_8$1
XFILLER_18_387 VDD VSS VDD VSS gf180mcu_fd_sc_mcu7t5v0__fillcap_8$1
X_429_ VDD VSS dac_gp[20] _747_/Q _756_/Q VDD VSS gf180mcu_fd_sc_mcu7t5v0__nand2_1$1
Xu_adc.ckg.t\[3\].wch.g\[0\].d.u VDD u_adc.ckg.t\[3\].ug/A1 VSS u_adc.ckg.t\[3\].wch.g\[0\].d.u/Z
+ VDD VSS gf180mcu_fd_sc_mcu7t5v0__dlyd_1$1
X_780_ _780_/D _780_/Q RSTN VSS _802_/CLK VDD VDD VSS gf180mcu_fd_sc_mcu7t5v0__dffrnq_1$1
XFILLER_11_541 VDD VSS VDD VSS gf180mcu_fd_sc_mcu7t5v0__fillcap_4$1
Xsw\[1\].u_ipg VDD VSS sw_ipg[1] _450_/ZN VDD VSS gf180mcu_fd_sc_mcu7t5v0__clkinv_4$1
Xu_tie_CS_PU CS_PU VDD VSS VDD VSS gf180mcu_fd_sc_mcu7t5v0__tiel$1
X_694_ _678_/C VDD VSS _695_/C _699_/A1 _695_/A2 VDD VSS gf180mcu_fd_sc_mcu7t5v0__nand3_1$1
X_763_ _763_/D _763_/Q RSTN VSS _802_/CLK VDD VDD VSS gf180mcu_fd_sc_mcu7t5v0__dffrnq_1$1
XFILLER_7_320 VDD VSS VDD VSS gf180mcu_fd_sc_mcu7t5v0__fillcap_8$1
XFILLER_16_2 VDD VSS VDD VSS gf180mcu_fd_sc_mcu7t5v0__fillcap_4$1
X_677_ _635_/S VDD VSS _679_/A1 _781_/Q _677_/A2 VDD VSS gf180mcu_fd_sc_mcu7t5v0__nor3_1$1
X_746_ _746_/D _746_/Q _775_/RN VSS _802_/CLK VDD VDD VSS gf180mcu_fd_sc_mcu7t5v0__dffrnq_1$1
XFILLER_16_441 VDD VSS VDD VSS gf180mcu_fd_sc_mcu7t5v0__fillcap_8$1
XFILLER_1_359 VDD VSS VDD VSS gf180mcu_fd_sc_mcu7t5v0__fillcap_16$1
X_600_ VDD VSS _602_/B _691_/B _604_/B1 VDD VSS gf180mcu_fd_sc_mcu7t5v0__and2_1$1
X_531_ _530_/Z VDD VSS _739_/D _567_/C _531_/A2 VDD VSS gf180mcu_fd_sc_mcu7t5v0__and3_1$1
X_462_ _466_/S VDD VSS _714_/D _714_/Q _713_/Q VDD VSS gf180mcu_fd_sc_mcu7t5v0__mux2_2$1
X_393_ _394_/A3 VDD VSS _532_/B _364_/Z _385_/Z VDD VSS gf180mcu_fd_sc_mcu7t5v0__and3_1$1
XFILLER_4_131 VDD VSS VDD VSS gf180mcu_fd_sc_mcu7t5v0__fillcap_4$1
XFILLER_5_632 VDD VSS VDD VSS gf180mcu_fd_sc_mcu7t5v0__fillcap_4$1
X_729_ _729_/D _729_/Q _775_/RN VSS _802_/CLK VDD VDD VSS gf180mcu_fd_sc_mcu7t5v0__dffrnq_1$1
X_514_ _374_/Z VDD VSS _685_/A2 _364_/Z _514_/A2 VDD VSS gf180mcu_fd_sc_mcu7t5v0__nor3_1$1
X_445_ VDD VSS _445_/ZN _793_/Q _798_/Q VDD VSS gf180mcu_fd_sc_mcu7t5v0__nand2_1$1
X_376_ VDD VSS _570_/A1 _502_/A1 _725_/Q VDD VSS gf180mcu_fd_sc_mcu7t5v0__nor2_1$1
XFILLER_18_311 VDD VSS VDD VSS gf180mcu_fd_sc_mcu7t5v0__fillcap_4$1
X_428_ VDD VSS dac_gp[19] _747_/Q _755_/Q VDD VSS gf180mcu_fd_sc_mcu7t5v0__nand2_1$1
X_359_ VDD VSS _803_/I CS _732_/Q VDD VSS gf180mcu_fd_sc_mcu7t5v0__or2_2$1
XFILLER_7_546 VDD VSS VDD VSS gf180mcu_fd_sc_mcu7t5v0__fillcap_8$1
XFILLER_12_328 VDD VSS VDD VSS gf180mcu_fd_sc_mcu7t5v0__fillcap_4$1
X_762_ _762_/D _762_/Q RSTN VSS _802_/CLK VDD VDD VSS gf180mcu_fd_sc_mcu7t5v0__dffrnq_1$1
X_693_ VDD VSS _785_/D _685_/C _693_/A2 VDD VSS gf180mcu_fd_sc_mcu7t5v0__nor2_1$1
XFILLER_16_667 VDD VSS VDD VSS gf180mcu_fd_sc_mcu7t5v0__fillcap_64$1
Xu_tie_RSTN_PD RSTN_PD VDD VSS VDD VSS gf180mcu_fd_sc_mcu7t5v0__tieh$1
XFILLER_0_596 VDD VSS VDD VSS gf180mcu_fd_sc_mcu7t5v0__fillcap_16$1
X_676_ _676_/B _676_/C VDD VSS _780_/D _691_/A1 _499_/C VDD VSS gf180mcu_fd_sc_mcu7t5v0__aoi211_1$1
X_745_ _745_/D _745_/Q RSTN VSS _802_/CLK VDD VDD VSS gf180mcu_fd_sc_mcu7t5v0__dffrnq_1$1
X_461_ _466_/S VDD VSS _713_/D _713_/Q _712_/Q VDD VSS gf180mcu_fd_sc_mcu7t5v0__mux2_2$1
X_530_ _689_/A3 VDD VSS _530_/Z _738_/Q _689_/A2 VDD VSS gf180mcu_fd_sc_mcu7t5v0__or3_1$1
XFILLER_17_206 VDD VSS VDD VSS gf180mcu_fd_sc_mcu7t5v0__fillcap_4$1
Xsw\[2\].u_rec VDD VSS sw_rec[2] _449_/ZN VDD VSS gf180mcu_fd_sc_mcu7t5v0__clkinv_4$1
X_392_ _392_/A3 VDD VSS _396_/B _364_/Z _394_/A3 VDD VSS gf180mcu_fd_sc_mcu7t5v0__nand3_1$1
X_728_ _728_/D _728_/Q _775_/RN VSS _802_/CLK VDD VDD VSS gf180mcu_fd_sc_mcu7t5v0__dffrnq_1$1
X_659_ VDD VSS _773_/D _653_/B _659_/A2 VDD VSS gf180mcu_fd_sc_mcu7t5v0__nor2_1$1
X_513_ VDD VSS _683_/A1 _532_/B _635_/S VDD VSS gf180mcu_fd_sc_mcu7t5v0__nor2_1$1
X_444_ VDD VSS dac_gp[11] _733_/Q _744_/Q VDD VSS gf180mcu_fd_sc_mcu7t5v0__nand2_1$1
X_375_ _543_/A3 VDD VSS _378_/A3 _800_/D _515_/A2 VDD VSS gf180mcu_fd_sc_mcu7t5v0__nand3_1$1
XFILLER_11_702 VDD VSS VDD VSS gf180mcu_fd_sc_mcu7t5v0__fillcap_16$1
XFILLER_6_2 VDD VSS VDD VSS gf180mcu_fd_sc_mcu7t5v0__fillcap_8$1
Xu_adc.ckg.t\[1\].nxt.ch.g\[3\].d.u VDD u_adc.ckg.t\[1\].nxt.ch.g\[3\].d.u/I VSS u_adc.ckg.t\[1\].ug/A1
+ VDD VSS gf180mcu_fd_sc_mcu7t5v0__dlyd_1$1
X_427_ VDD VSS dac_gp[18] _747_/Q _754_/Q VDD VSS gf180mcu_fd_sc_mcu7t5v0__nand2_1$1
X_358_ VDD VSS _804_/I CS _746_/Q VDD VSS gf180mcu_fd_sc_mcu7t5v0__or2_2$1
XFILLER_5_282 VDD VSS VDD VSS gf180mcu_fd_sc_mcu7t5v0__fillcap_8$1
Xsw\[1\].u_rec_b sw_rec_b[1] VSS VDD _451_/ZN VDD VSS gf180mcu_fd_sc_mcu7t5v0__clkbuf_8$1
XFILLER_2_241 VDD VSS VDD VSS gf180mcu_fd_sc_mcu7t5v0__fillcap_4$1
Xu_tie_DIN_PD DIN_PD VDD VSS VDD VSS gf180mcu_fd_sc_mcu7t5v0__tiel$1
X_761_ _761_/D _761_/Q _775_/RN VSS _802_/CLK VDD VDD VSS gf180mcu_fd_sc_mcu7t5v0__dffrnq_1$1
X_692_ _692_/B _692_/C VDD VSS _693_/A2 _785_/Q _691_/B VDD VSS gf180mcu_fd_sc_mcu7t5v0__aoi211_1$1
XFILLER_15_189 VDD VSS VDD VSS gf180mcu_fd_sc_mcu7t5v0__fillcap_16$1
XFILLER_15_690 VDD VSS VDD VSS gf180mcu_fd_sc_mcu7t5v0__fillcap_8$1
XFILLER_4_325 VDD VSS VDD VSS gf180mcu_fd_sc_mcu7t5v0__fillcap_8$1
X_744_ _744_/D _744_/Q RSTN VSS _802_/CLK VDD VDD VSS gf180mcu_fd_sc_mcu7t5v0__dffrnq_1$1
X_675_ VDD _676_/C _678_/C _779_/Q _689_/A2 VSS _499_/C VDD VSS gf180mcu_fd_sc_mcu7t5v0__oai31_1$1
X_391_ _385_/Z _489_/A2 _390_/Z VDD VSS _392_/A3 _729_/Q _559_/A1 VDD VSS gf180mcu_fd_sc_mcu7t5v0__oai32_1$1
X_460_ _466_/S VDD VSS _712_/D _712_/Q DIN VDD VSS gf180mcu_fd_sc_mcu7t5v0__mux2_2$1
XFILLER_4_37 VDD VSS VDD VSS gf180mcu_fd_sc_mcu7t5v0__fillcap_16$1
XFILLER_4_177 VDD VSS VDD VSS gf180mcu_fd_sc_mcu7t5v0__fillcap_8$1
X_727_ _727_/D _727_/Q _775_/RN VSS _802_/CLK VDD VDD VSS gf180mcu_fd_sc_mcu7t5v0__dffrnq_1$1
X_658_ _695_/B _658_/C VDD VSS _659_/A2 _789_/Q _695_/A2 _773_/Q VDD VSS gf180mcu_fd_sc_mcu7t5v0__oai221_1$1
X_589_ VDD VSS _591_/A1 _683_/A1 _594_/A2 VDD VSS gf180mcu_fd_sc_mcu7t5v0__nand2_1$1
XFILLER_16_240 VDD VSS VDD VSS gf180mcu_fd_sc_mcu7t5v0__fillcap_4$1
XFILLER_16_295 VDD VSS VDD VSS gf180mcu_fd_sc_mcu7t5v0__fillcap_8$1
X_374_ VDD VSS _374_/Z _726_/Q _725_/Q VDD VSS gf180mcu_fd_sc_mcu7t5v0__or2_1$2
X_512_ VDD VSS _736_/D _512_/A1 _512_/A2 VDD VSS gf180mcu_fd_sc_mcu7t5v0__nor2_1$1
X_443_ VDD VSS dac_gp[10] _733_/Q _745_/Q VDD VSS gf180mcu_fd_sc_mcu7t5v0__nand2_1$1
XFILLER_5_80 VDD VSS VDD VSS gf180mcu_fd_sc_mcu7t5v0__fillcap_4$1
XFILLER_7_718 VDD VSS VDD VSS gf180mcu_fd_sc_mcu7t5v0__fillcap_8$1
X_426_ VDD VSS dac_gp[17] _747_/Q _753_/Q VDD VSS gf180mcu_fd_sc_mcu7t5v0__nand2_1$1
X_357_ VDD VSS _805_/I CS _760_/Q VDD VSS gf180mcu_fd_sc_mcu7t5v0__or2_1$2
XFILLER_5_272 VDD VSS VDD VSS gf180mcu_fd_sc_mcu7t5v0__fillcap_8$1
XFILLER_19_78 VDD VSS VDD VSS gf180mcu_fd_sc_mcu7t5v0__fillcap_8$1
X_409_ VDD VSS dac_gp[24] _761_/Q _762_/Q VDD VSS gf180mcu_fd_sc_mcu7t5v0__nand2_1$1
XFILLER_4_518 VDD VSS VDD VSS gf180mcu_fd_sc_mcu7t5v0__fillcap_4$1
Xu_adc.ckg.t\[1\].nxt.ch.g\[2\].d.u VDD u_adc.ckg.t\[1\].nxt.ch.g\[2\].d.u/I VSS u_adc.ckg.t\[1\].nxt.ch.g\[3\].d.u/I
+ VDD VSS gf180mcu_fd_sc_mcu7t5v0__dlyd_1$1
X_760_ _760_/D _760_/Q _775_/RN VSS _802_/CLK VDD VDD VSS gf180mcu_fd_sc_mcu7t5v0__dffrnq_1$1
X_691_ _691_/B _691_/C VDD VSS _692_/C _691_/A1 _691_/A2 VDD VSS gf180mcu_fd_sc_mcu7t5v0__aoi211_1$1
X_674_ _677_/A2 VDD VSS _676_/B _780_/Q _499_/C VDD VSS gf180mcu_fd_sc_mcu7t5v0__nor3_1$1
X_743_ _743_/D _743_/Q RSTN VSS _802_/CLK VDD VDD VSS gf180mcu_fd_sc_mcu7t5v0__dffrnq_1$1
XFILLER_7_142 VDD VSS VDD VSS gf180mcu_fd_sc_mcu7t5v0__fillcap_4$1
XFILLER_14_2 VDD VSS VDD VSS gf180mcu_fd_sc_mcu7t5v0__fillcap_8$1
X_390_ VDD VSS _390_/Z _729_/Q _730_/Q VDD VSS gf180mcu_fd_sc_mcu7t5v0__xor2_1$1
XFILLER_4_123 VDD VSS VDD VSS gf180mcu_fd_sc_mcu7t5v0__fillcap_8$1
X_657_ _652_/B VDD VSS _658_/C _771_/Q _689_/A2 VDD VSS gf180mcu_fd_sc_mcu7t5v0__or3_1$1
X_726_ _726_/D _726_/Q _775_/RN VSS _802_/CLK VDD VDD VSS gf180mcu_fd_sc_mcu7t5v0__dffrnq_1$1
X_588_ VDD VSS _594_/A2 _752_/Q _685_/A2 VDD VSS gf180mcu_fd_sc_mcu7t5v0__nor2_1$1
X_511_ _678_/B1 _567_/C VDD VSS _512_/A2 _735_/Q _689_/A2 _791_/Q VDD VSS gf180mcu_fd_sc_mcu7t5v0__oai221_1$1
X_442_ VDD VSS dac_gp[9] _733_/Q _743_/Q VDD VSS gf180mcu_fd_sc_mcu7t5v0__nand2_1$1
X_373_ VDD VSS _543_/A3 _726_/Q _725_/Q VDD VSS gf180mcu_fd_sc_mcu7t5v0__nor2_1$1
XFILLER_0_181 VDD VSS VDD VSS gf180mcu_fd_sc_mcu7t5v0__fillcap_16$1
X_709_ VDD VSS dac_gn[46] _787_/Q _711_/A2 VDD VSS gf180mcu_fd_sc_mcu7t5v0__nor2_1$1
XFILLER_17_572 VDD VSS VDD VSS gf180mcu_fd_sc_mcu7t5v0__fillcap_4$1
XFILLER_8_270 VDD VSS VDD VSS gf180mcu_fd_sc_mcu7t5v0__fillcap_16$1
XFILLER_10_225 VDD VSS VDD VSS gf180mcu_fd_sc_mcu7t5v0__fillcap_16$1
XFILLER_11_726 VDD VSS VDD VSS gf180mcu_fd_sc_mcu7t5v0__fillcap_4$1
XFILLER_10_247 VDD VSS VDD VSS gf180mcu_fd_sc_mcu7t5v0__fillcap_8$1
X_356_ VDD VSS _806_/I _774_/Q CS VDD VSS gf180mcu_fd_sc_mcu7t5v0__or2_1$2
X_425_ VDD VSS dac_gp[16] _747_/Q _752_/Q VDD VSS gf180mcu_fd_sc_mcu7t5v0__nand2_1$1
XFILLER_10_37 VDD VSS VDD VSS gf180mcu_fd_sc_mcu7t5v0__fillcap_16$1
XFILLER_18_177 VDD VSS VDD VSS gf180mcu_fd_sc_mcu7t5v0__fillcap_64$1
X_408_ VDD VSS dac_gp[47] _786_/Q _775_/Q VDD VSS gf180mcu_fd_sc_mcu7t5v0__nand2_1$1
X_339_ VDD VSS dac_gn[19] _343_/A1 _755_/Q VDD VSS gf180mcu_fd_sc_mcu7t5v0__nor2_1$1
XFILLER_6_571 VDD VSS VDD VSS gf180mcu_fd_sc_mcu7t5v0__fillcap_8$1
X_690_ _689_/Z VDD VSS _784_/D _678_/C _690_/A2 VDD VSS gf180mcu_fd_sc_mcu7t5v0__and3_1$1
XFILLER_15_136 VDD VSS VDD VSS gf180mcu_fd_sc_mcu7t5v0__fillcap_4$1
X_673_ _673_/B _685_/C VDD VSS _779_/D _532_/B _673_/A2 VDD VSS gf180mcu_fd_sc_mcu7t5v0__aoi211_1$1
X_742_ _742_/D _742_/Q RSTN VSS _802_/CLK VDD VDD VSS gf180mcu_fd_sc_mcu7t5v0__dffrnq_1$1
XFILLER_12_651 VDD VSS VDD VSS gf180mcu_fd_sc_mcu7t5v0__fillcap_8$1
XFILLER_7_198 VDD VSS VDD VSS gf180mcu_fd_sc_mcu7t5v0__fillcap_8$1
Xu_adc.ckg.t\[1\].nxt.ch.g\[1\].d.u VDD u_adc.ckg.t\[1\].nxt.ch.g\[1\].d.u/I VSS u_adc.ckg.t\[1\].nxt.ch.g\[2\].d.u/I
+ VDD VSS gf180mcu_fd_sc_mcu7t5v0__dlyd_1$1
Xu_adc.ckg.t\[0\].first.ch.g\[14\].genblk1.genblk1.a.u VSS u_adc.ckg.t\[0\].ug/A1
+ u_adc.ckg.t\[0\].first.ch.g\[14\].genblk1.genblk1.a.u/I VDD VDD VSS gf180mcu_fd_sc_mcu7t5v0__dlya_1$1
X_725_ _725_/D _725_/Q _775_/RN VSS _802_/CLK VDD VDD VSS gf180mcu_fd_sc_mcu7t5v0__dffrnq_1$1
X_656_ VDD _656_/B _656_/A2 _772_/D _656_/A1 VSS VDD VSS gf180mcu_fd_sc_mcu7t5v0__oai21_1$1
X_587_ VDD VSS _751_/D _587_/A1 _587_/A2 VDD VSS gf180mcu_fd_sc_mcu7t5v0__nor2_1$1
Xu_adc.ckg.t\[0\].ug _733_/Q VDD VSS cmp_clk[0] u_adc.ckg.t\[0\].ug/A1 u_adc.ckg.t\[0\].ui/ZN
+ VDD VSS gf180mcu_fd_sc_mcu7t5v0__and3_1$1
X_441_ VDD VSS dac_gp[8] _733_/Q _742_/Q VDD VSS gf180mcu_fd_sc_mcu7t5v0__nand2_1$1
X_510_ _635_/S VDD VSS _512_/A1 _736_/Q _677_/A2 VDD VSS gf180mcu_fd_sc_mcu7t5v0__nor3_1$1
Xsw\[2\].u_ipg_b sw_ipg_b[2] VSS VDD _448_/ZN VDD VSS gf180mcu_fd_sc_mcu7t5v0__clkbuf_8$1
X_372_ _515_/A2 VDD VSS _378_/A2 _799_/D _560_/A1 VDD VSS gf180mcu_fd_sc_mcu7t5v0__nand3_1$1
XFILLER_13_201 VDD VSS VDD VSS gf180mcu_fd_sc_mcu7t5v0__fillcap_8$1
XFILLER_13_212 VDD VSS VDD VSS gf180mcu_fd_sc_mcu7t5v0__fillcap_4$1
XFILLER_1_672 VDD VSS VDD VSS gf180mcu_fd_sc_mcu7t5v0__fillcap_16$1
X_708_ VDD VSS dac_gn[45] _785_/Q _711_/A2 VDD VSS gf180mcu_fd_sc_mcu7t5v0__nor2_1$1
X_639_ _689_/A3 VDD VSS _639_/Z _768_/Q _684_/A2 VDD VSS gf180mcu_fd_sc_mcu7t5v0__or3_1$1
XFILLER_17_562 VDD VSS VDD VSS gf180mcu_fd_sc_mcu7t5v0__fillcap_4$1
X_424_ VDD VSS dac_gp[15] _747_/Q _751_/Q VDD VSS gf180mcu_fd_sc_mcu7t5v0__nand2_1$1
X_355_ VDD VSS dac_gn[11] _493_/A1 _744_/Q VDD VSS gf180mcu_fd_sc_mcu7t5v0__nor2_1$1
XFILLER_19_36 VDD VSS VDD VSS gf180mcu_fd_sc_mcu7t5v0__fillcap_16$1
XFILLER_4_2 VDD VSS VDD VSS gf180mcu_fd_sc_mcu7t5v0__fillcap_8$1
X_338_ VDD VSS dac_gn[18] _343_/A1 _754_/Q VDD VSS gf180mcu_fd_sc_mcu7t5v0__nor2_1$1
X_407_ VDD VSS dac_gp[46] _787_/Q _775_/Q VDD VSS gf180mcu_fd_sc_mcu7t5v0__nand2_1$1
XFILLER_14_351 VDD VSS VDD VSS gf180mcu_fd_sc_mcu7t5v0__fillcap_8$1
XFILLER_2_72 VDD VSS VDD VSS gf180mcu_fd_sc_mcu7t5v0__fillcap_32$1
XFILLER_16_605 VDD VSS VDD VSS gf180mcu_fd_sc_mcu7t5v0__fillcap_4$1
XFILLER_19_410 VDD VSS VDD VSS gf180mcu_fd_sc_mcu7t5v0__fillcap_4$1
XFILLER_12_107 VDD VSS VDD VSS gf180mcu_fd_sc_mcu7t5v0__fillcap_16$1
XFILLER_16_37 VDD VSS VDD VSS gf180mcu_fd_sc_mcu7t5v0__fillcap_64$1
XFILLER_0_567 VDD VSS VDD VSS gf180mcu_fd_sc_mcu7t5v0__fillcap_8$1
X_672_ _499_/C _672_/B1 _788_/Q VDD VSS _673_/B _779_/Q _672_/A2 VDD VSS gf180mcu_fd_sc_mcu7t5v0__oai32_1$1
X_741_ _741_/D _741_/Q RSTN VSS _802_/CLK VDD VDD VSS gf180mcu_fd_sc_mcu7t5v0__dffrnq_1$1
XFILLER_16_457 VDD VSS VDD VSS gf180mcu_fd_sc_mcu7t5v0__fillcap_16$1
XFILLER_8_667 VDD VSS VDD VSS gf180mcu_fd_sc_mcu7t5v0__fillcap_64$1
XFILLER_19_240 VDD VSS VDD VSS gf180mcu_fd_sc_mcu7t5v0__fillcap_32$1
XFILLER_4_18 VDD VSS VDD VSS gf180mcu_fd_sc_mcu7t5v0__fillcap_16$1
XFILLER_4_169 VDD VSS VDD VSS gf180mcu_fd_sc_mcu7t5v0__fillcap_4$1
XFILLER_5_648 VDD VSS VDD VSS gf180mcu_fd_sc_mcu7t5v0__fillcap_32$1
XFILLER_0_342 VDD VSS VDD VSS gf180mcu_fd_sc_mcu7t5v0__fillcap_32$1
X_724_ _724_/D rst_amp_o RSTN VSS _802_/CLK VDD VDD VSS gf180mcu_fd_sc_mcu7t5v0__dffrnq_1$1
X_655_ _689_/A2 _678_/C _789_/Q VDD VSS _656_/A2 _773_/Q VDD VSS gf180mcu_fd_sc_mcu7t5v0__oai22_1$1
X_586_ _678_/B1 _601_/B VDD VSS _587_/A2 _750_/Q _689_/A2 _790_/Q VDD VSS gf180mcu_fd_sc_mcu7t5v0__oai221_1$1
XFILLER_16_232 VDD VSS VDD VSS gf180mcu_fd_sc_mcu7t5v0__fillcap_8$1
X_440_ VDD VSS dac_gp[7] _733_/Q _741_/Q VDD VSS gf180mcu_fd_sc_mcu7t5v0__nand2_1$1
X_371_ VDD VSS _514_/A2 _728_/Q _542_/A2 VDD VSS gf180mcu_fd_sc_mcu7t5v0__nand2_1$1
Xu_adc.ckg.t\[1\].nxt.ch.g\[0\].d.u VDD u_adc.ckg.t\[0\].ug/A1 VSS u_adc.ckg.t\[1\].nxt.ch.g\[1\].d.u/I
+ VDD VSS gf180mcu_fd_sc_mcu7t5v0__dlyd_1$1
XFILLER_13_257 VDD VSS VDD VSS gf180mcu_fd_sc_mcu7t5v0__fillcap_4$1
XFILLER_1_640 VDD VSS VDD VSS gf180mcu_fd_sc_mcu7t5v0__fillcap_32$1
X_707_ VDD VSS dac_gn[44] _784_/Q _711_/A2 VDD VSS gf180mcu_fd_sc_mcu7t5v0__nor2_1$1
X_638_ _638_/B _653_/B VDD VSS _767_/D _683_/A1 _640_/A2 VDD VSS gf180mcu_fd_sc_mcu7t5v0__aoi211_1$1
X_569_ VDD VSS _666_/A2 _569_/A1 _569_/A2 VDD VSS gf180mcu_fd_sc_mcu7t5v0__nor2_1$1
XFILLER_5_72 VDD VSS VDD VSS gf180mcu_fd_sc_mcu7t5v0__fillcap_8$1
X_423_ VDD VSS dac_gp[14] _747_/Q _750_/Q VDD VSS gf180mcu_fd_sc_mcu7t5v0__nand2_1$1
X_354_ VDD VSS dac_gn[10] _493_/A1 _745_/Q VDD VSS gf180mcu_fd_sc_mcu7t5v0__nor2_1$1
XFILLER_3_702 VDD VSS VDD VSS gf180mcu_fd_sc_mcu7t5v0__fillcap_16$1
XFILLER_19_614 VDD VSS VDD VSS gf180mcu_fd_sc_mcu7t5v0__fillcap_32$1
XFILLER_18_146 VDD VSS VDD VSS gf180mcu_fd_sc_mcu7t5v0__fillcap_4$1
X_337_ VDD VSS dac_gn[17] _343_/A1 _753_/Q VDD VSS gf180mcu_fd_sc_mcu7t5v0__nor2_1$1
X_406_ VDD VSS dac_gp[45] _785_/Q _775_/Q VDD VSS gf180mcu_fd_sc_mcu7t5v0__nand2_1$1
XFILLER_0_716 VDD VSS VDD VSS gf180mcu_fd_sc_mcu7t5v0__fillcap_16$1
XFILLER_11_60 VDD VSS VDD VSS gf180mcu_fd_sc_mcu7t5v0__fillcap_8$1
XFILLER_19_444 VDD VSS VDD VSS gf180mcu_fd_sc_mcu7t5v0__fillcap_32$1
Xu_adc.ch\[3\].utg VDD _806_/I VSS tg_on[3] VDD VSS gf180mcu_fd_sc_mcu7t5v0__dlyd_1$1
X_740_ _740_/D _740_/Q RSTN VSS _802_/CLK VDD VDD VSS gf180mcu_fd_sc_mcu7t5v0__dffrnq_1$1
X_671_ VDD VSS _778_/D _671_/A1 _671_/A2 VDD VSS gf180mcu_fd_sc_mcu7t5v0__nor2_1$1
XFILLER_8_646 VDD VSS VDD VSS gf180mcu_fd_sc_mcu7t5v0__fillcap_16$1
XFILLER_19_274 VDD VSS VDD VSS gf180mcu_fd_sc_mcu7t5v0__fillcap_32$1
XFILLER_0_376 VDD VSS VDD VSS gf180mcu_fd_sc_mcu7t5v0__fillcap_32$1
X_654_ _685_/C VDD VSS _656_/A1 _772_/Q _532_/B VDD VSS gf180mcu_fd_sc_mcu7t5v0__nor3_1$1
X_723_ _723_/D _723_/Q RSTN VSS _802_/CLK VDD VDD VSS gf180mcu_fd_sc_mcu7t5v0__dffrnq_1$1
X_585_ _635_/S VDD VSS _587_/A1 _751_/Q _677_/A2 VDD VSS gf180mcu_fd_sc_mcu7t5v0__nor3_1$1
Xu_adc.ckg.t\[0\].ui VSS u_adc.ckg.t\[0\].ui/ZN _791_/CLK VDD VDD VSS gf180mcu_fd_sc_mcu7t5v0__inv_1$1
XFILLER_12_2 VDD VSS VDD VSS gf180mcu_fd_sc_mcu7t5v0__fillcap_8$1
X_370_ VDD VSS _515_/A2 _481_/A1 _727_/Q VDD VSS gf180mcu_fd_sc_mcu7t5v0__nor2_1$1
Xu_adc.ckg.t\[0\].first.ch.g\[12\].d.u VDD u_adc.ckg.t\[0\].first.ch.g\[12\].d.u/I
+ VSS u_adc.ckg.t\[0\].first.ch.g\[12\].d.u/Z VDD VSS gf180mcu_fd_sc_mcu7t5v0__dlyd_1$1
XFILLER_1_696 VDD VSS VDD VSS gf180mcu_fd_sc_mcu7t5v0__fillcap_4$1
X_706_ VDD VSS dac_gn[43] _783_/Q _711_/A2 VDD VSS gf180mcu_fd_sc_mcu7t5v0__nor2_1$1
X_637_ VDD VSS _640_/A2 _767_/Q _685_/A2 VDD VSS gf180mcu_fd_sc_mcu7t5v0__nor2_1$1
X_499_ _734_/Q _499_/C VDD VSS _500_/A2 _791_/Q _669_/A2 _499_/B1 VDD VSS gf180mcu_fd_sc_mcu7t5v0__aoi221_1$1
X_568_ VDD VSS _745_/D _568_/A1 _568_/A2 VDD VSS gf180mcu_fd_sc_mcu7t5v0__nor2_1$1
XFILLER_11_718 VDD VSS VDD VSS gf180mcu_fd_sc_mcu7t5v0__fillcap_8$1
XFILLER_2_449 VDD VSS VDD VSS gf180mcu_fd_sc_mcu7t5v0__fillcap_4$1
XFILLER_18_317 VDD VSS VDD VSS gf180mcu_fd_sc_mcu7t5v0__fillcap_32$1
XFILLER_14_501 VDD VSS VDD VSS gf180mcu_fd_sc_mcu7t5v0__fillcap_16$1
X_353_ VDD VSS dac_gn[9] _493_/A1 _743_/Q VDD VSS gf180mcu_fd_sc_mcu7t5v0__nor2_1$1
X_422_ VDD VSS dac_gp[13] _747_/Q _749_/Q VDD VSS gf180mcu_fd_sc_mcu7t5v0__nand2_1$1
Xu_adc.ckg.t\[1\].wch.g\[0\].d.u VDD u_adc.ckg.t\[1\].ug/A1 VSS u_adc.ckg.t\[1\].wch.g\[0\].d.u/Z
+ VDD VSS gf180mcu_fd_sc_mcu7t5v0__dlyd_1$1
XFILLER_2_257 VDD VSS VDD VSS gf180mcu_fd_sc_mcu7t5v0__fillcap_8$1
XFILLER_19_648 VDD VSS VDD VSS gf180mcu_fd_sc_mcu7t5v0__fillcap_32$1
X_336_ VDD VSS dac_gn[16] _343_/A1 _752_/Q VDD VSS gf180mcu_fd_sc_mcu7t5v0__nor2_1$1
X_405_ VDD VSS dac_gp[44] _784_/Q _775_/Q VDD VSS gf180mcu_fd_sc_mcu7t5v0__nand2_1$1
XFILLER_11_72 VDD VSS VDD VSS gf180mcu_fd_sc_mcu7t5v0__fillcap_8$1
XFILLER_19_478 VDD VSS VDD VSS gf180mcu_fd_sc_mcu7t5v0__fillcap_8$1
Xu_adc.ckg.t\[3\].ug _775_/Q VDD VSS cmp_clk[3] u_adc.ckg.t\[3\].ug/A1 u_adc.ckg.t\[3\].ui/ZN
+ VDD VSS gf180mcu_fd_sc_mcu7t5v0__and3_1$1
X_319_ VDD VSS tg_on[0] dac_gdn[0] VDD VSS gf180mcu_fd_sc_mcu7t5v0__clkinv_1$1
X_670_ _670_/B1 _678_/C VDD VSS _671_/A2 _777_/Q _689_/A2 _788_/Q VDD VSS gf180mcu_fd_sc_mcu7t5v0__oai221_1$1
XFILLER_11_142 VDD VSS VDD VSS gf180mcu_fd_sc_mcu7t5v0__fillcap_16$1
X_799_ _799_/D hold5/I RSTN VSS _802_/CLK VDD VDD VSS gf180mcu_fd_sc_mcu7t5v0__dffrnq_1$1
XFILLER_5_606 VDD VSS VDD VSS gf180mcu_fd_sc_mcu7t5v0__fillcap_16$1
X_722_ _722_/D _802_/D RSTN VSS _802_/CLK VDD VDD VSS gf180mcu_fd_sc_mcu7t5v0__dffrnq_1$1
X_653_ _653_/B VDD VSS _771_/D _653_/A1 _653_/A2 VDD VSS gf180mcu_fd_sc_mcu7t5v0__aoi21_1$1
XFILLER_17_702 VDD VSS VDD VSS gf180mcu_fd_sc_mcu7t5v0__fillcap_16$1
X_584_ VDD VSS _590_/B1 _751_/Q _635_/S VDD VSS gf180mcu_fd_sc_mcu7t5v0__nor2_1$1
XFILLER_3_193 VDD VSS VDD VSS gf180mcu_fd_sc_mcu7t5v0__fillcap_16$1
Xu_adc.ch\[2\].utg VDD _805_/I VSS tg_on[2] VDD VSS gf180mcu_fd_sc_mcu7t5v0__dlyd_1$1
XFILLER_13_29 VDD VSS VDD VSS gf180mcu_fd_sc_mcu7t5v0__fillcap_32$1
X_636_ VDD VSS _638_/B _683_/A1 _635_/Z VDD VSS gf180mcu_fd_sc_mcu7t5v0__nor2_1$1
X_705_ VDD VSS dac_gn[42] _782_/Q _711_/A2 VDD VSS gf180mcu_fd_sc_mcu7t5v0__nor2_1$1
X_567_ _614_/A1 _567_/C VDD VSS _568_/A2 _791_/Q _656_/B _745_/Q VDD VSS gf180mcu_fd_sc_mcu7t5v0__oai221_1$1
X_498_ VDD VSS _499_/C _514_/A2 _521_/A2 VDD VSS gf180mcu_fd_sc_mcu7t5v0__nor2_2$1
X_421_ VDD VSS dac_gp[12] _747_/Q _748_/Q VDD VSS gf180mcu_fd_sc_mcu7t5v0__nand2_1$1
X_352_ VDD VSS dac_gn[8] _493_/A1 _742_/Q VDD VSS gf180mcu_fd_sc_mcu7t5v0__nor2_1$1
X_619_ VDD _664_/B _689_/A2 _622_/A1 _786_/Q VSS VDD VSS gf180mcu_fd_sc_mcu7t5v0__oai21_1$1
XFILLER_17_384 VDD VSS VDD VSS gf180mcu_fd_sc_mcu7t5v0__fillcap_16$1
Xu_adc.ckg.t\[0\].first.ch.g\[11\].d.u VDD u_adc.ckg.t\[0\].first.ch.g\[11\].d.u/I
+ VSS u_adc.ckg.t\[0\].first.ch.g\[12\].d.u/I VDD VSS gf180mcu_fd_sc_mcu7t5v0__dlyd_1$1
XFILLER_3_726 VDD VSS VDD VSS gf180mcu_fd_sc_mcu7t5v0__fillcap_4$1
XFILLER_19_605 VDD VSS VDD VSS gf180mcu_fd_sc_mcu7t5v0__fillcap_4$1
X_404_ VDD VSS dac_gp[43] _783_/Q _775_/Q VDD VSS gf180mcu_fd_sc_mcu7t5v0__nand2_1$1
X_335_ VDD VSS dac_gn[15] _343_/A1 _751_/Q VDD VSS gf180mcu_fd_sc_mcu7t5v0__nor2_1$1
XFILLER_15_674 VDD VSS VDD VSS gf180mcu_fd_sc_mcu7t5v0__fillcap_16$1
X_318_ VDD VSS tg_on[1] dac_gdn[1] VDD VSS gf180mcu_fd_sc_mcu7t5v0__clkinv_1$1
Xu_adc.ckg.t\[2\].nxt.ch.g\[3\].d.u VDD u_adc.ckg.t\[2\].nxt.ch.g\[3\].d.u/I VSS u_adc.ckg.t\[2\].ug/A1
+ VDD VSS gf180mcu_fd_sc_mcu7t5v0__dlyd_1$1
XFILLER_0_537 VDD VSS VDD VSS gf180mcu_fd_sc_mcu7t5v0__fillcap_4$1
XFILLER_16_449 VDD VSS VDD VSS gf180mcu_fd_sc_mcu7t5v0__fillcap_4$1
XFILLER_11_198 VDD VSS VDD VSS gf180mcu_fd_sc_mcu7t5v0__fillcap_8$1
X_798_ hold3/Z _798_/Q RSTN VSS _802_/CLK VDD VDD VSS gf180mcu_fd_sc_mcu7t5v0__dffrnq_1$1
Xu_adc.ckg.t\[0\].wch.g\[1\].genblk1.c.u _791_/CLK VSS u_adc.ckg.t\[0\].wch.g\[0\].d.u/Z
+ VDD VDD VSS gf180mcu_fd_sc_mcu7t5v0__dlyc_1$1
X_721_ _721_/D _801_/D RSTN VSS _802_/CLK VDD VDD VSS gf180mcu_fd_sc_mcu7t5v0__dffrnq_1$1
X_652_ _652_/B VDD VSS _653_/A2 _771_/Q _652_/A2 VDD VSS gf180mcu_fd_sc_mcu7t5v0__aoi21_1$1
X_583_ _583_/B _583_/C VDD VSS _750_/D _609_/A1 _499_/C VDD VSS gf180mcu_fd_sc_mcu7t5v0__aoi211_1$1
XFILLER_17_72 VDD VSS VDD VSS gf180mcu_fd_sc_mcu7t5v0__fillcap_4$1
XFILLER_16_257 VDD VSS VDD VSS gf180mcu_fd_sc_mcu7t5v0__fillcap_4$1
XFILLER_15_290 VDD VSS VDD VSS gf180mcu_fd_sc_mcu7t5v0__fillcap_8$1
XFILLER_13_249 VDD VSS VDD VSS gf180mcu_fd_sc_mcu7t5v0__fillcap_8$1
X_704_ VDD VSS dac_gn[38] _778_/Q _711_/A2 VDD VSS gf180mcu_fd_sc_mcu7t5v0__nor2_1$1
XFILLER_0_197 VDD VSS VDD VSS gf180mcu_fd_sc_mcu7t5v0__fillcap_4$1
X_635_ _635_/S VDD VSS _635_/Z _766_/Q _789_/Q VDD VSS gf180mcu_fd_sc_mcu7t5v0__mux2_2$1
X_566_ _601_/B VDD VSS _614_/A1 _689_/A2 _656_/B VDD VSS gf180mcu_fd_sc_mcu7t5v0__nand3_1$1
X_497_ VDD VSS _521_/A2 _543_/A1 _379_/Z VDD VSS gf180mcu_fd_sc_mcu7t5v0__nand2_1$1
X_420_ VDD VSS dac_gp[35] _761_/Q _772_/Q VDD VSS gf180mcu_fd_sc_mcu7t5v0__nand2_1$1
X_351_ VDD VSS dac_gn[7] _493_/A1 _741_/Q VDD VSS gf180mcu_fd_sc_mcu7t5v0__nor2_1$1
XFILLER_5_256 VDD VSS VDD VSS gf180mcu_fd_sc_mcu7t5v0__fillcap_16$1
Xu_adc.ch\[1\].utg VDD _804_/I VSS tg_on[1] VDD VSS gf180mcu_fd_sc_mcu7t5v0__dlyd_1$1
X_618_ VDD _656_/B _666_/A2 _761_/D _618_/A1 VSS VDD VSS gf180mcu_fd_sc_mcu7t5v0__oai21_1$1
X_549_ _678_/C VDD VSS _695_/B _689_/A2 _695_/A2 VDD VSS gf180mcu_fd_sc_mcu7t5v0__nand3_1$1
XFILLER_19_29 VDD VSS VDD VSS gf180mcu_fd_sc_mcu7t5v0__fillcap_4$1
XFILLER_18_116 VDD VSS VDD VSS gf180mcu_fd_sc_mcu7t5v0__fillcap_4$1
X_403_ VDD VSS dac_gp[42] _782_/Q _775_/Q VDD VSS gf180mcu_fd_sc_mcu7t5v0__nand2_1$1
XFILLER_14_377 VDD VSS VDD VSS gf180mcu_fd_sc_mcu7t5v0__fillcap_8$1
X_334_ VDD VSS dac_gn[14] _343_/A1 _750_/Q VDD VSS gf180mcu_fd_sc_mcu7t5v0__nor2_1$1
XFILLER_18_661 VDD VSS VDD VSS gf180mcu_fd_sc_mcu7t5v0__fillcap_4$1
X_317_ VDD VSS tg_on[2] dac_gdn[2] VDD VSS gf180mcu_fd_sc_mcu7t5v0__clkinv_1$1
Xu_adc.ckg.t\[3\].ui VSS u_adc.ckg.t\[3\].ui/ZN _788_/CLK VDD VDD VSS gf180mcu_fd_sc_mcu7t5v0__inv_1$1
XFILLER_15_642 VDD VSS VDD VSS gf180mcu_fd_sc_mcu7t5v0__fillcap_32$1
Xu_adc.ckg.t\[0\].first.ch.g\[10\].d.u VDD u_adc.ckg.t\[0\].first.ch.g\[9\].d.u/Z
+ VSS u_adc.ckg.t\[0\].first.ch.g\[11\].d.u/I VDD VSS gf180mcu_fd_sc_mcu7t5v0__dlyd_1$1
Xsw\[0\].u_ipg VDD VSS sw_ipg[0] _452_/ZN VDD VSS gf180mcu_fd_sc_mcu7t5v0__clkinv_4$1
XFILLER_12_667 VDD VSS VDD VSS gf180mcu_fd_sc_mcu7t5v0__fillcap_64$1
XFILLER_11_166 VDD VSS VDD VSS gf180mcu_fd_sc_mcu7t5v0__fillcap_32$1
X_797_ hold4/Z _797_/Q RSTN VSS _802_/CLK VDD VDD VSS gf180mcu_fd_sc_mcu7t5v0__dffrnq_1$1
XFILLER_7_693 VDD VSS VDD VSS gf180mcu_fd_sc_mcu7t5v0__fillcap_4$1
XFILLER_4_107 VDD VSS VDD VSS gf180mcu_fd_sc_mcu7t5v0__fillcap_16$1
X_720_ _720_/D _800_/D RSTN VSS _802_/CLK VDD VDD VSS gf180mcu_fd_sc_mcu7t5v0__dffrnq_1$1
X_651_ _651_/B _651_/C VDD VSS _653_/A1 _789_/Q _697_/S VDD VSS gf180mcu_fd_sc_mcu7t5v0__oai211_1$1
X_582_ VDD _583_/C _601_/B _749_/Q _689_/A2 VSS _499_/C VDD VSS gf180mcu_fd_sc_mcu7t5v0__oai31_1$1
XFILLER_16_247 VDD VSS VDD VSS gf180mcu_fd_sc_mcu7t5v0__fillcap_4$1
XFILLER_17_726 VDD VSS VDD VSS gf180mcu_fd_sc_mcu7t5v0__fillcap_4$1
Xu_adc.ckg.t\[2\].nxt.ch.g\[2\].d.u VDD u_adc.ckg.t\[2\].nxt.ch.g\[2\].d.u/I VSS u_adc.ckg.t\[2\].nxt.ch.g\[3\].d.u/I
+ VDD VSS gf180mcu_fd_sc_mcu7t5v0__dlyd_1$1
Xhold2 hold2/Z VSS hold2/I VDD VDD VSS gf180mcu_fd_sc_mcu7t5v0__dlyc_1$1
XFILLER_1_688 VDD VSS VDD VSS gf180mcu_fd_sc_mcu7t5v0__fillcap_8$1
X_703_ VDD VSS dac_gn[39] _779_/Q _711_/A2 VDD VSS gf180mcu_fd_sc_mcu7t5v0__nor2_1$1
XFILLER_0_154 VDD VSS VDD VSS gf180mcu_fd_sc_mcu7t5v0__fillcap_16$1
X_634_ VDD VSS _766_/D _634_/A1 _634_/A2 VDD VSS gf180mcu_fd_sc_mcu7t5v0__nor2_1$1
X_565_ VDD VSS _568_/A1 _743_/Q _689_/A2 VDD VSS gf180mcu_fd_sc_mcu7t5v0__nor2_1$1
X_496_ VDD VSS _672_/A2 _689_/A2 _672_/B1 VDD VSS gf180mcu_fd_sc_mcu7t5v0__nand2_1$1
XFILLER_10_2 VDD VSS VDD VSS gf180mcu_fd_sc_mcu7t5v0__fillcap_32$1
X_350_ VDD VSS dac_gn[6] _493_/A1 _740_/Q VDD VSS gf180mcu_fd_sc_mcu7t5v0__nor2_1$1
XFILLER_14_96 VDD VSS VDD VSS gf180mcu_fd_sc_mcu7t5v0__fillcap_8$1
XFILLER_1_463 VDD VSS VDD VSS gf180mcu_fd_sc_mcu7t5v0__fillcap_4$1
X_617_ VDD VSS _760_/D _760_/Q _661_/A2 VDD VSS gf180mcu_fd_sc_mcu7t5v0__or2_1$2
Xu_tie_DOUT_CS DOUT_CS VDD VSS VDD VSS gf180mcu_fd_sc_mcu7t5v0__tiel$1
X_479_ VDD VSS _727_/D _727_/Q _379_/Z VDD VSS gf180mcu_fd_sc_mcu7t5v0__xor2_1$1
X_548_ VDD VSS _662_/A2 _532_/B _685_/C VDD VSS gf180mcu_fd_sc_mcu7t5v0__nor2_1$1
X_333_ VDD VSS dac_gn[13] _343_/A1 _749_/Q VDD VSS gf180mcu_fd_sc_mcu7t5v0__nor2_1$1
X_402_ VDD VSS dac_gp[41] _781_/Q _775_/Q VDD VSS gf180mcu_fd_sc_mcu7t5v0__nand2_1$1
XFILLER_3_536 VDD VSS VDD VSS gf180mcu_fd_sc_mcu7t5v0__fillcap_4$1
Xu_adc.ch\[0\].utg VDD _803_/I VSS tg_on[0] VDD VSS gf180mcu_fd_sc_mcu7t5v0__dlyd_1$1
X_316_ VDD VSS tg_on[3] dac_gdn[3] VDD VSS gf180mcu_fd_sc_mcu7t5v0__clkinv_1$1
XFILLER_0_506 VDD VSS VDD VSS gf180mcu_fd_sc_mcu7t5v0__fillcap_4$1
Xu_adc.ckg.t\[0\].first.ch.g\[9\].d.u VDD u_adc.ckg.t\[0\].first.ch.g\[9\].d.u/I VSS
+ u_adc.ckg.t\[0\].first.ch.g\[9\].d.u/Z VDD VSS gf180mcu_fd_sc_mcu7t5v0__dlyd_1$1
X_796_ hold2/Z _796_/Q RSTN VSS _802_/CLK VDD VDD VSS gf180mcu_fd_sc_mcu7t5v0__dffrnq_1$1
XFILLER_15_473 VDD VSS VDD VSS gf180mcu_fd_sc_mcu7t5v0__fillcap_4$1
X_650_ _650_/B _650_/C VDD VSS _770_/D _532_/B _650_/A2 VDD VSS gf180mcu_fd_sc_mcu7t5v0__aoi211_1$1
X_581_ _677_/A2 VDD VSS _583_/B _750_/Q _499_/C VDD VSS gf180mcu_fd_sc_mcu7t5v0__nor3_1$1
Xhold3 hold3/Z VSS hold3/I VDD VDD VSS gf180mcu_fd_sc_mcu7t5v0__dlyc_1$1
X_779_ _779_/D _779_/Q RSTN VSS _802_/CLK VDD VDD VSS gf180mcu_fd_sc_mcu7t5v0__dffrnq_1$1
Xsw\[0\].u_rec_b sw_rec_b[0] VSS VDD _453_/ZN VDD VSS gf180mcu_fd_sc_mcu7t5v0__clkbuf_8$1
X_633_ _678_/B1 _656_/B VDD VSS _634_/A2 _765_/Q _689_/A2 _789_/Q VDD VSS gf180mcu_fd_sc_mcu7t5v0__oai221_1$1
X_702_ VDD VSS dac_gn[40] _780_/Q _711_/A2 VDD VSS gf180mcu_fd_sc_mcu7t5v0__nor2_1$1
Xsw\[1\].u_rec VDD VSS sw_rec[1] _451_/ZN VDD VSS gf180mcu_fd_sc_mcu7t5v0__clkinv_4$1
XFILLER_17_535 VDD VSS VDD VSS gf180mcu_fd_sc_mcu7t5v0__fillcap_16$1
XFILLER_12_240 VDD VSS VDD VSS gf180mcu_fd_sc_mcu7t5v0__fillcap_4$1
X_495_ VDD VSS _499_/B1 _532_/B _669_/A2 VDD VSS gf180mcu_fd_sc_mcu7t5v0__nor2_1$1
X_564_ _564_/A3 VDD VSS _744_/D _567_/C _564_/A2 VDD VSS gf180mcu_fd_sc_mcu7t5v0__nand3_1$1
XFILLER_8_222 VDD VSS VDD VSS gf180mcu_fd_sc_mcu7t5v0__fillcap_16$1
XFILLER_5_66 VDD VSS VDD VSS gf180mcu_fd_sc_mcu7t5v0__fillcap_4$1
Xu_adc.ckg.t\[2\].nxt.ch.g\[1\].d.u VDD u_adc.ckg.t\[2\].nxt.ch.g\[1\].d.u/I VSS u_adc.ckg.t\[2\].nxt.ch.g\[2\].d.u/I
+ VDD VSS gf180mcu_fd_sc_mcu7t5v0__dlyd_1$1
XFILLER_1_486 VDD VSS VDD VSS gf180mcu_fd_sc_mcu7t5v0__fillcap_4$1
XFILLER_1_475 VDD VSS VDD VSS gf180mcu_fd_sc_mcu7t5v0__fillcap_4$1
X_547_ VDD VSS _678_/C _379_/Z _560_/A2 VDD VSS gf180mcu_fd_sc_mcu7t5v0__nand2_1$1
X_616_ VDD VSS _663_/A2 _379_/Z _616_/A2 VDD VSS gf180mcu_fd_sc_mcu7t5v0__nand2_1$1
X_478_ VDD VSS _726_/D _560_/A1 _570_/A1 VDD VSS gf180mcu_fd_sc_mcu7t5v0__or2_1$2
XFILLER_3_718 VDD VSS VDD VSS gf180mcu_fd_sc_mcu7t5v0__fillcap_8$1
X_401_ VDD VSS dac_gp[40] _780_/Q _775_/Q VDD VSS gf180mcu_fd_sc_mcu7t5v0__nand2_1$1
X_332_ VDD VSS dac_gn[12] _343_/A1 _748_/Q VDD VSS gf180mcu_fd_sc_mcu7t5v0__nor2_1$1
XFILLER_2_45 VDD VSS VDD VSS gf180mcu_fd_sc_mcu7t5v0__fillcap_16$1
XFILLER_11_98 VDD VSS VDD VSS gf180mcu_fd_sc_mcu7t5v0__fillcap_4$1
X_315_ VDD VSS _775_/Q _711_/A2 VDD VSS gf180mcu_fd_sc_mcu7t5v0__clkinv_1$1
XFILLER_0_518 VDD VSS VDD VSS gf180mcu_fd_sc_mcu7t5v0__fillcap_4$1
X_795_ hold5/Z _795_/Q RSTN VSS _802_/CLK VDD VDD VSS gf180mcu_fd_sc_mcu7t5v0__dffrnq_1$1
Xu_adc.ckg.t\[0\].first.ch.g\[13\].genblk1.genblk1.a.u VSS u_adc.ckg.t\[0\].first.ch.g\[14\].genblk1.genblk1.a.u/I
+ u_adc.ckg.t\[0\].first.ch.g\[12\].d.u/Z VDD VDD VSS gf180mcu_fd_sc_mcu7t5v0__dlya_1$1
X_580_ _580_/B _604_/C VDD VSS _749_/D _532_/B _580_/A2 VDD VSS gf180mcu_fd_sc_mcu7t5v0__aoi211_1$1
XFILLER_3_142 VDD VSS VDD VSS gf180mcu_fd_sc_mcu7t5v0__fillcap_8$1
Xhold4 hold4/Z VSS hold4/I VDD VDD VSS gf180mcu_fd_sc_mcu7t5v0__dlyc_1$1
X_778_ _778_/D _778_/Q RSTN VSS _802_/CLK VDD VDD VSS gf180mcu_fd_sc_mcu7t5v0__dffrnq_1$1
Xu_adc.ckg.t\[0\].first.ch.g\[8\].d.u VDD u_adc.ckg.t\[0\].first.ch.g\[8\].d.u/I VSS
+ u_adc.ckg.t\[0\].first.ch.g\[9\].d.u/I VDD VSS gf180mcu_fd_sc_mcu7t5v0__dlyd_1$1
X_701_ VDD VSS dac_gn[41] _781_/Q _711_/A2 VDD VSS gf180mcu_fd_sc_mcu7t5v0__nor2_1$1
X_632_ _635_/S VDD VSS _634_/A1 _766_/Q _677_/A2 VDD VSS gf180mcu_fd_sc_mcu7t5v0__nor3_1$1
X_563_ _601_/B _563_/C VDD VSS _564_/A3 _745_/Q _689_/A2 VDD VSS gf180mcu_fd_sc_mcu7t5v0__oai211_1$1
XFILLER_9_702 VDD VSS VDD VSS gf180mcu_fd_sc_mcu7t5v0__fillcap_16$1
XFILLER_12_263 VDD VSS VDD VSS gf180mcu_fd_sc_mcu7t5v0__fillcap_8$1
X_494_ _672_/B1 VDD VSS _500_/A1 _758_/Q _532_/B VDD VSS gf180mcu_fd_sc_mcu7t5v0__nand3_1$1
XFILLER_14_10 VDD VSS VDD VSS gf180mcu_fd_sc_mcu7t5v0__fillcap_4$1
X_546_ VDD VSS _685_/C _615_/A1 _559_/A2 VDD VSS gf180mcu_fd_sc_mcu7t5v0__nor2_1$1
X_615_ VDD VSS _661_/A2 _615_/A1 _459_/B VDD VSS gf180mcu_fd_sc_mcu7t5v0__nor2_1$1
X_477_ _725_/Q VDD VSS _725_/D _731_/Q _477_/A2 VDD VSS gf180mcu_fd_sc_mcu7t5v0__aoi21_1$1
X_331_ VDD VSS dac_gn[35] _618_/A1 _772_/Q VDD VSS gf180mcu_fd_sc_mcu7t5v0__nor2_1$1
X_400_ VDD VSS dac_gp[39] _779_/Q _775_/Q VDD VSS gf180mcu_fd_sc_mcu7t5v0__nand2_1$1
XFILLER_6_579 VDD VSS VDD VSS gf180mcu_fd_sc_mcu7t5v0__fillcap_4$1
X_529_ _688_/B1 _537_/A2 VDD VSS _531_/A2 _529_/A1 _689_/A3 VDD VSS gf180mcu_fd_sc_mcu7t5v0__aoi22_1$1
Xu_adc.ckg.t\[2\].nxt.ch.g\[0\].d.u VDD u_adc.ckg.t\[1\].ug/A1 VSS u_adc.ckg.t\[2\].nxt.ch.g\[1\].d.u/I
+ VDD VSS gf180mcu_fd_sc_mcu7t5v0__dlyd_1$1
XFILLER_11_44 VDD VSS VDD VSS gf180mcu_fd_sc_mcu7t5v0__fillcap_16$1
X_314_ VDD VSS _786_/Q _696_/A1 VDD VSS gf180mcu_fd_sc_mcu7t5v0__clkinv_1$1
XFILLER_14_155 VDD VSS VDD VSS gf180mcu_fd_sc_mcu7t5v0__fillcap_8$1
XFILLER_14_177 VDD VSS VDD VSS gf180mcu_fd_sc_mcu7t5v0__fillcap_4$1
XFILLER_12_659 VDD VSS VDD VSS gf180mcu_fd_sc_mcu7t5v0__fillcap_4$1
Xu_adc.ckg.t\[3\].wch.g\[1\].genblk1.c.u _788_/CLK VSS u_adc.ckg.t\[3\].wch.g\[0\].d.u/Z
+ VDD VDD VSS gf180mcu_fd_sc_mcu7t5v0__dlyc_1$1
X_794_ VSS _802_/CLK VDD _794_/D _794_/Q RSTN VDD VSS gf180mcu_fd_sc_mcu7t5v0__dffsnq_1$1
XFILLER_7_685 VDD VSS VDD VSS gf180mcu_fd_sc_mcu7t5v0__fillcap_8$1
XFILLER_17_718 VDD VSS VDD VSS gf180mcu_fd_sc_mcu7t5v0__fillcap_8$1
Xhold5 hold5/Z VSS hold5/I VDD VDD VSS gf180mcu_fd_sc_mcu7t5v0__dlyc_1$1
X_777_ _777_/D _777_/Q RSTN VSS _802_/CLK VDD VDD VSS gf180mcu_fd_sc_mcu7t5v0__dffrnq_1$1
X_700_ VDD VSS dac_gn[36] _776_/Q _711_/A2 VDD VSS gf180mcu_fd_sc_mcu7t5v0__nor2_1$1
X_631_ _631_/B _631_/C VDD VSS _765_/D _644_/A1 _499_/C VDD VSS gf180mcu_fd_sc_mcu7t5v0__aoi211_1$1
X_562_ VDD VSS _563_/C _744_/Q _532_/B VDD VSS gf180mcu_fd_sc_mcu7t5v0__or2_1$2
X_493_ VDD _567_/C _669_/A2 _733_/D _493_/A1 VSS VDD VSS gf180mcu_fd_sc_mcu7t5v0__oai21_1$1
XFILLER_8_202 VDD VSS VDD VSS gf180mcu_fd_sc_mcu7t5v0__fillcap_4$1
XFILLER_8_257 VDD VSS VDD VSS gf180mcu_fd_sc_mcu7t5v0__fillcap_4$1
Xu_adc.ckg.t\[0\].first.ch.g\[7\].d.u VDD u_adc.ckg.t\[0\].first.ch.g\[7\].d.u/I VSS
+ u_adc.ckg.t\[0\].first.ch.g\[8\].d.u/I VDD VSS gf180mcu_fd_sc_mcu7t5v0__dlyd_1$1
X_476_ _476_/S VDD VSS _724_/D _717_/Q rst_amp_o VDD VSS gf180mcu_fd_sc_mcu7t5v0__mux2_2$1
X_545_ _545_/B _558_/B VDD VSS _741_/D _652_/A2 _550_/A2 VDD VSS gf180mcu_fd_sc_mcu7t5v0__aoi211_1$1
X_614_ VDD _614_/B _614_/A2 _759_/D _614_/A1 VSS VDD VSS gf180mcu_fd_sc_mcu7t5v0__oai21_1$1
X_330_ VDD VSS dac_gn[34] _618_/A1 _773_/Q VDD VSS gf180mcu_fd_sc_mcu7t5v0__nor2_1$1
XFILLER_17_142 VDD VSS VDD VSS gf180mcu_fd_sc_mcu7t5v0__fillcap_64$1
X_459_ VDD _459_/B _559_/A2 _466_/S _379_/Z VSS VDD VSS gf180mcu_fd_sc_mcu7t5v0__oai21_1$1
X_528_ VDD VSS _537_/A2 _739_/Q _691_/A2 VDD VSS gf180mcu_fd_sc_mcu7t5v0__nor2_1$1
XFILLER_14_167 VDD VSS VDD VSS gf180mcu_fd_sc_mcu7t5v0__fillcap_8$1
X_313_ VDD VSS RSTN _360_/A2 VDD VSS gf180mcu_fd_sc_mcu7t5v0__clkinv_1$1
X_793_ _793_/D _793_/Q RSTN VSS _802_/CLK VDD VDD VSS gf180mcu_fd_sc_mcu7t5v0__dffrnq_1$1
Xsw\[1\].u_ipg_b sw_ipg_b[1] VSS VDD _450_/ZN VDD VSS gf180mcu_fd_sc_mcu7t5v0__clkbuf_8$1
Xu_tie_SCLK_PD SCLK_PD VDD VSS VDD VSS gf180mcu_fd_sc_mcu7t5v0__tiel$1
XFILLER_17_55 VDD VSS VDD VSS gf180mcu_fd_sc_mcu7t5v0__fillcap_4$1
XFILLER_4_667 VDD VSS VDD VSS gf180mcu_fd_sc_mcu7t5v0__fillcap_64$1
X_776_ _776_/D _776_/Q RSTN VSS _802_/CLK VDD VDD VSS gf180mcu_fd_sc_mcu7t5v0__dffrnq_1$1
XFILLER_15_240 VDD VSS VDD VSS gf180mcu_fd_sc_mcu7t5v0__fillcap_16$1
X_630_ VDD _631_/C _656_/B _764_/Q _689_/A2 VSS _499_/C VDD VSS gf180mcu_fd_sc_mcu7t5v0__oai31_1$1
X_492_ VDD VSS _672_/B1 _543_/A3 _616_/A2 VDD VSS gf180mcu_fd_sc_mcu7t5v0__nand2_1$1
X_561_ VDD VSS _564_/A2 _791_/Q _604_/C VDD VSS gf180mcu_fd_sc_mcu7t5v0__nand2_1$1
XFILLER_9_726 VDD VSS VDD VSS gf180mcu_fd_sc_mcu7t5v0__fillcap_4$1
X_759_ _759_/D _759_/Q RSTN VSS _802_/CLK VDD VDD VSS gf180mcu_fd_sc_mcu7t5v0__dffrnq_1$1
X_613_ _790_/Q _653_/B VDD VSS _614_/B _757_/Q _532_/B _685_/C VDD VSS gf180mcu_fd_sc_mcu7t5v0__aoi221_1$1
X_475_ _476_/S VDD VSS _723_/D _716_/Q _723_/Q VDD VSS gf180mcu_fd_sc_mcu7t5v0__mux2_2$1
X_544_ VDD VSS _550_/A2 _741_/Q _652_/B VDD VSS gf180mcu_fd_sc_mcu7t5v0__nor2_1$1
XFILLER_9_556 VDD VSS VDD VSS gf180mcu_fd_sc_mcu7t5v0__fillcap_4$1
X_527_ VDD VSS _691_/A2 _533_/A2 _569_/A2 VDD VSS gf180mcu_fd_sc_mcu7t5v0__nor2_1$1
XFILLER_17_132 VDD VSS VDD VSS gf180mcu_fd_sc_mcu7t5v0__fillcap_8$1
X_458_ VDD VSS _559_/A2 _543_/A1 _467_/A3 VDD VSS gf180mcu_fd_sc_mcu7t5v0__nand2_1$1
X_389_ VDD VSS _489_/A2 _543_/A3 _467_/A3 VDD VSS gf180mcu_fd_sc_mcu7t5v0__nand2_1$1
Xu_adc.ckg.t\[0\].first.ch.g\[6\].d.u VDD u_adc.ckg.t\[0\].first.ch.g\[6\].d.u/I VSS
+ u_adc.ckg.t\[0\].first.ch.g\[7\].d.u/I VDD VSS gf180mcu_fd_sc_mcu7t5v0__dlyd_1$1
X_312_ VDD VSS _732_/Q _488_/A1 VDD VSS gf180mcu_fd_sc_mcu7t5v0__clkinv_1$1
Xu_oe VDD VSS DOUT_OE CS VDD VSS gf180mcu_fd_sc_mcu7t5v0__clkinv_20$1
X_792_ _792_/D DOUT _775_/RN VDD VSS _802_/CLK VDD VSS gf180mcu_fd_sc_mcu7t5v0__dffnsnq_4$1
XFILLER_15_422 VDD VSS VDD VSS gf180mcu_fd_sc_mcu7t5v0__fillcap_16$1
XFILLER_6_186 VDD VSS VDD VSS gf180mcu_fd_sc_mcu7t5v0__fillcap_32$1
X_775_ _775_/D _775_/Q _775_/RN VSS _802_/CLK VDD VDD VSS gf180mcu_fd_sc_mcu7t5v0__dffrnq_1$1
XFILLER_19_580 VDD VSS VDD VSS gf180mcu_fd_sc_mcu7t5v0__fillcap_4$1
XFILLER_0_104 VDD VSS VDD VSS gf180mcu_fd_sc_mcu7t5v0__fillcap_4$1
X_560_ VDD VSS _601_/B _560_/A1 _560_/A2 VDD VSS gf180mcu_fd_sc_mcu7t5v0__nand2_1$1
X_491_ VDD VSS _669_/A2 _374_/Z _459_/B VDD VSS gf180mcu_fd_sc_mcu7t5v0__nor2_1$1
XFILLER_0_682 VDD VSS VDD VSS gf180mcu_fd_sc_mcu7t5v0__fillcap_32$1
Xu_adc.ckg.t\[3\].nxt.ch.g\[3\].d.u VDD u_adc.ckg.t\[3\].nxt.ch.g\[3\].d.u/I VSS u_adc.ckg.t\[3\].ug/A1
+ VDD VSS gf180mcu_fd_sc_mcu7t5v0__dlyd_1$1
X_689_ _689_/A3 VDD VSS _689_/Z _783_/Q _689_/A2 VDD VSS gf180mcu_fd_sc_mcu7t5v0__or3_1$1
X_758_ _758_/D _758_/Q RSTN VSS _802_/CLK VDD VDD VSS gf180mcu_fd_sc_mcu7t5v0__dffrnq_1$1
XFILLER_16_561 VDD VSS VDD VSS gf180mcu_fd_sc_mcu7t5v0__fillcap_32$1
X_543_ _543_/A3 VDD VSS _695_/A2 _543_/A1 _687_/A1 VDD VSS gf180mcu_fd_sc_mcu7t5v0__nand3_1$1
X_612_ VDD VSS _614_/A2 _759_/Q _678_/C VDD VSS gf180mcu_fd_sc_mcu7t5v0__nand2_1$1
X_474_ _476_/S VDD VSS _722_/D _715_/Q _802_/D VDD VSS gf180mcu_fd_sc_mcu7t5v0__mux2_2$1
XFILLER_9_2 VDD VSS VDD VSS gf180mcu_fd_sc_mcu7t5v0__fillcap_64$1
XFILLER_18_667 VDD VSS VDD VSS gf180mcu_fd_sc_mcu7t5v0__fillcap_64$1
X_526_ _570_/A1 VDD VSS _649_/A2 _543_/A1 _687_/A1 VDD VSS gf180mcu_fd_sc_mcu7t5v0__nand3_1$1
X_388_ VDD _731_/Q _730_/Q _394_/A3 _729_/Q VSS VDD VSS gf180mcu_fd_sc_mcu7t5v0__oai21_1$1
X_457_ VDD VSS _560_/A2 _364_/Z _385_/Z VDD VSS gf180mcu_fd_sc_mcu7t5v0__nor2_1$1
XFILLER_6_324 VDD VSS VDD VSS gf180mcu_fd_sc_mcu7t5v0__fillcap_8$1
X_311_ VDD VSS _791_/Q _529_/A1 VDD VSS gf180mcu_fd_sc_mcu7t5v0__clkinv_1$1
X_509_ _514_/A2 VDD VSS _635_/S _364_/Z _559_/A1 VDD VSS gf180mcu_fd_sc_mcu7t5v0__nor3_4$1
XFILLER_19_206 VDD VSS VDD VSS gf180mcu_fd_sc_mcu7t5v0__fillcap_32$1
X_791_ VDD _791_/Q _791_/CLK VSS cmp_q[0] VDD VSS gf180mcu_fd_sc_mcu7t5v0__dffq_1$1
XFILLER_6_165 VDD VSS VDD VSS gf180mcu_fd_sc_mcu7t5v0__fillcap_8$1
XFILLER_8_37 VDD VSS VDD VSS gf180mcu_fd_sc_mcu7t5v0__fillcap_16$1
Xu_adc.ckg.t\[0\].first.ch.g\[5\].d.u VDD u_adc.ckg.t\[0\].first.ch.g\[5\].d.u/I VSS
+ u_adc.ckg.t\[0\].first.ch.g\[6\].d.u/I VDD VSS gf180mcu_fd_sc_mcu7t5v0__dlyd_1$1
XFILLER_0_308 VDD VSS VDD VSS gf180mcu_fd_sc_mcu7t5v0__fillcap_32$1
X_774_ _774_/D _774_/Q _775_/RN VSS _802_/CLK VDD VDD VSS gf180mcu_fd_sc_mcu7t5v0__dffrnq_1$1
XFILLER_1_617 VDD VSS VDD VSS gf180mcu_fd_sc_mcu7t5v0__fillcap_4$1
XFILLER_0_138 VDD VSS VDD VSS gf180mcu_fd_sc_mcu7t5v0__fillcap_8$1
X_490_ VDD VSS _567_/C _543_/A3 _560_/A2 VDD VSS gf180mcu_fd_sc_mcu7t5v0__nand2_1$1
XFILLER_13_702 VDD VSS VDD VSS gf180mcu_fd_sc_mcu7t5v0__fillcap_16$1
XFILLER_8_238 VDD VSS VDD VSS gf180mcu_fd_sc_mcu7t5v0__fillcap_4$1
X_688_ _688_/B1 _691_/C VDD VSS _690_/A2 _691_/A1 _689_/A3 VDD VSS gf180mcu_fd_sc_mcu7t5v0__aoi22_1$1
X_757_ _757_/D _757_/Q RSTN VSS _802_/CLK VDD VDD VSS gf180mcu_fd_sc_mcu7t5v0__dffrnq_1$1
XFILLER_7_271 VDD VSS VDD VSS gf180mcu_fd_sc_mcu7t5v0__fillcap_8$1
X_542_ _364_/Z _374_/Z VDD VSS _652_/B _728_/Q _542_/A2 VDD VSS gf180mcu_fd_sc_mcu7t5v0__nor4_1$1
X_473_ _476_/S VDD VSS _721_/D _714_/Q _801_/D VDD VSS gf180mcu_fd_sc_mcu7t5v0__mux2_2$1
X_611_ VDD VSS _611_/I _758_/D VDD VSS gf180mcu_fd_sc_mcu7t5v0__clkinv_1$1
Xu_adc.ckg.t\[3\].nxt.ch.g\[2\].d.u VDD u_adc.ckg.t\[3\].nxt.ch.g\[2\].d.u/I VSS u_adc.ckg.t\[3\].nxt.ch.g\[3\].d.u/I
+ VDD VSS gf180mcu_fd_sc_mcu7t5v0__dlyd_1$1
XFILLER_10_535 VDD VSS VDD VSS gf180mcu_fd_sc_mcu7t5v0__fillcap_4$1
X_456_ _543_/A1 VDD VSS _459_/B _728_/Q _727_/Q VDD VSS gf180mcu_fd_sc_mcu7t5v0__nand3_1$1
X_525_ VDD VSS _688_/B1 _532_/B _689_/A3 VDD VSS gf180mcu_fd_sc_mcu7t5v0__nor2_1$1
X_387_ _387_/B _387_/C VDD VSS _396_/A2 _801_/D _387_/A2 VDD VSS gf180mcu_fd_sc_mcu7t5v0__aoi211_1$1
X_310_ VDD VSS _742_/Q _553_/A1 VDD VSS gf180mcu_fd_sc_mcu7t5v0__clkinv_1$1
XFILLER_10_310 VDD VSS VDD VSS gf180mcu_fd_sc_mcu7t5v0__fillcap_4$1
X_439_ VDD VSS dac_gp[6] _733_/Q _740_/Q VDD VSS gf180mcu_fd_sc_mcu7t5v0__nand2_1$1
XFILLER_9_130 VDD VSS VDD VSS gf180mcu_fd_sc_mcu7t5v0__fillcap_8$1
X_508_ VDD VSS _677_/A2 _689_/A2 _678_/B1 VDD VSS gf180mcu_fd_sc_mcu7t5v0__nand2_1$1
X_790_ VDD _790_/Q _790_/CLK VSS cmp_q[1] VDD VSS gf180mcu_fd_sc_mcu7t5v0__dffq_1$1
XFILLER_6_177 VDD VSS VDD VSS gf180mcu_fd_sc_mcu7t5v0__fillcap_4$1
XFILLER_17_47 VDD VSS VDD VSS gf180mcu_fd_sc_mcu7t5v0__fillcap_8$1
XFILLER_3_136 VDD VSS VDD VSS gf180mcu_fd_sc_mcu7t5v0__fillcap_4$1
X_773_ _773_/D _773_/Q RSTN VSS _802_/CLK VDD VDD VSS gf180mcu_fd_sc_mcu7t5v0__dffrnq_1$1
XFILLER_9_718 VDD VSS VDD VSS gf180mcu_fd_sc_mcu7t5v0__fillcap_8$1
Xu_adc.ckg.t\[0\].first.ch.g\[4\].d.u VDD u_adc.ckg.t\[0\].first.ch.g\[4\].d.u/I VSS
+ u_adc.ckg.t\[0\].first.ch.g\[5\].d.u/I VDD VSS gf180mcu_fd_sc_mcu7t5v0__dlyd_1$1
X_756_ _756_/D _756_/Q RSTN VSS _802_/CLK VDD VDD VSS gf180mcu_fd_sc_mcu7t5v0__dffrnq_1$1
X_687_ _784_/Q VDD VSS _691_/C _687_/A1 _687_/A2 VDD VSS gf180mcu_fd_sc_mcu7t5v0__aoi21_1$1
X_610_ _614_/A1 _610_/C VDD VSS _611_/I _759_/Q _689_/A2 _758_/Q VDD VSS gf180mcu_fd_sc_mcu7t5v0__oai221_1$1
X_472_ _476_/S VDD VSS _720_/D _713_/Q _800_/D VDD VSS gf180mcu_fd_sc_mcu7t5v0__mux2_2$1
X_541_ VDD VSS _545_/B _652_/A2 _540_/Z VDD VSS gf180mcu_fd_sc_mcu7t5v0__nor2_1$1
XFILLER_9_548 VDD VSS VDD VSS gf180mcu_fd_sc_mcu7t5v0__fillcap_8$1
X_739_ _739_/D _739_/Q RSTN VSS _802_/CLK VDD VDD VSS gf180mcu_fd_sc_mcu7t5v0__dffrnq_1$1
X_455_ VDD VSS _616_/A2 _364_/Z _569_/A1 VDD VSS gf180mcu_fd_sc_mcu7t5v0__nor2_1$1
X_386_ VDD _386_/B _385_/Z _387_/B _725_/Q VSS VDD VSS gf180mcu_fd_sc_mcu7t5v0__oai21_1$1
XFILLER_9_312 VDD VSS VDD VSS gf180mcu_fd_sc_mcu7t5v0__fillcap_4$1
X_524_ VDD VSS _738_/D _522_/Z _524_/A2 VDD VSS gf180mcu_fd_sc_mcu7t5v0__and2_1$1
X_438_ VDD VSS dac_gp[5] _733_/Q _739_/Q VDD VSS gf180mcu_fd_sc_mcu7t5v0__nand2_1$1
X_369_ _560_/A1 VDD VSS _378_/A1 _723_/Q _687_/A1 VDD VSS gf180mcu_fd_sc_mcu7t5v0__nand3_1$1
X_507_ _558_/B VDD VSS _735_/D _507_/A1 _507_/A2 VDD VSS gf180mcu_fd_sc_mcu7t5v0__aoi21_1$1
XFILLER_3_72 VDD VSS VDD VSS gf180mcu_fd_sc_mcu7t5v0__fillcap_64$1
Xu_adc.ckg.t\[3\].nxt.ch.g\[1\].d.u VDD u_adc.ckg.t\[3\].nxt.ch.g\[1\].d.u/I VSS u_adc.ckg.t\[3\].nxt.ch.g\[2\].d.u/I
+ VDD VSS gf180mcu_fd_sc_mcu7t5v0__dlyd_1$1
XFILLER_2_395 VDD VSS VDD VSS gf180mcu_fd_sc_mcu7t5v0__fillcap_4$1
XFILLER_18_241 VDD VSS VDD VSS gf180mcu_fd_sc_mcu7t5v0__fillcap_4$1
XFILLER_4_649 VDD VSS VDD VSS gf180mcu_fd_sc_mcu7t5v0__fillcap_16$1
X_772_ _772_/D _772_/Q RSTN VSS _802_/CLK VDD VDD VSS gf180mcu_fd_sc_mcu7t5v0__dffrnq_1$1
Xsw\[3\].u_ipg VDD VSS sw_ipg[3] _447_/ZN VDD VSS gf180mcu_fd_sc_mcu7t5v0__clkinv_4$1
XFILLER_0_40 VDD VSS VDD VSS gf180mcu_fd_sc_mcu7t5v0__fillcap_16$1
XFILLER_13_726 VDD VSS VDD VSS gf180mcu_fd_sc_mcu7t5v0__fillcap_4$1
XFILLER_12_247 VDD VSS VDD VSS gf180mcu_fd_sc_mcu7t5v0__fillcap_16$1
X_755_ _755_/D _755_/Q RSTN VSS _802_/CLK VDD VDD VSS gf180mcu_fd_sc_mcu7t5v0__dffrnq_1$1
X_686_ VDD VSS _783_/D _684_/Z _686_/A2 VDD VSS gf180mcu_fd_sc_mcu7t5v0__and2_1$1
XFILLER_16_597 VDD VSS VDD VSS gf180mcu_fd_sc_mcu7t5v0__fillcap_8$1
X_540_ _540_/S VDD VSS _540_/Z _740_/Q _791_/Q VDD VSS gf180mcu_fd_sc_mcu7t5v0__mux2_2$1
X_471_ _476_/S VDD VSS _719_/D _712_/Q _799_/D VDD VSS gf180mcu_fd_sc_mcu7t5v0__mux2_2$1
XFILLER_13_545 VDD VSS VDD VSS gf180mcu_fd_sc_mcu7t5v0__fillcap_4$1
X_669_ _669_/A3 VDD VSS _671_/A1 _778_/Q _669_/A2 VDD VSS gf180mcu_fd_sc_mcu7t5v0__nor3_1$1
X_738_ _738_/D _738_/Q RSTN VSS _802_/CLK VDD VDD VSS gf180mcu_fd_sc_mcu7t5v0__dffrnq_1$1
Xu_tie_DOUT_PD DOUT_PD VDD VSS VDD VSS gf180mcu_fd_sc_mcu7t5v0__tiel$1
Xu_adc.ckg.t\[0\].first.ch.g\[3\].d.u VDD u_adc.ckg.t\[0\].first.ch.g\[3\].d.u/I VSS
+ u_adc.ckg.t\[0\].first.ch.g\[4\].d.u/I VDD VSS gf180mcu_fd_sc_mcu7t5v0__dlyd_1$1
X_523_ _532_/B _558_/B VDD VSS _524_/A2 _529_/A1 _685_/A2 _523_/B1 VDD VSS gf180mcu_fd_sc_mcu7t5v0__aoi221_1$1
X_454_ VDD VSS _569_/A1 _728_/Q _727_/Q VDD VSS gf180mcu_fd_sc_mcu7t5v0__nand2_1$1
X_385_ VDD VSS _385_/Z _728_/Q _727_/Q VDD VSS gf180mcu_fd_sc_mcu7t5v0__or2_1$2
XFILLER_14_139 VDD VSS VDD VSS gf180mcu_fd_sc_mcu7t5v0__fillcap_16$1
XFILLER_7_2 VDD VSS VDD VSS gf180mcu_fd_sc_mcu7t5v0__fillcap_64$1
Xu_tie_RSTN_PU RSTN_PU VDD VSS VDD VSS gf180mcu_fd_sc_mcu7t5v0__tiel$1
X_506_ VSS VDD _735_/Q _506_/C1 _515_/A2 _687_/A2 _499_/C _791_/Q _507_/A2 VDD VSS
+ gf180mcu_fd_sc_mcu7t5v0__aoi222_1$1
X_299_ VDD VSS _726_/Q _502_/A1 VDD VSS gf180mcu_fd_sc_mcu7t5v0__clkinv_1$1
X_368_ VDD VSS _559_/A1 _502_/A1 _725_/Q VDD VSS gf180mcu_fd_sc_mcu7t5v0__nand2_1$1
X_437_ VDD VSS dac_gp[4] _733_/Q _738_/Q VDD VSS gf180mcu_fd_sc_mcu7t5v0__nand2_1$1
Xu_adc.ckg.t\[2\].ug _761_/Q VDD VSS cmp_clk[2] u_adc.ckg.t\[2\].ug/A1 u_adc.ckg.t\[2\].ui/ZN
+ VDD VSS gf180mcu_fd_sc_mcu7t5v0__and3_1$1
XFILLER_8_18 VDD VSS VDD VSS gf180mcu_fd_sc_mcu7t5v0__fillcap_16$1
XFILLER_7_669 VDD VSS VDD VSS gf180mcu_fd_sc_mcu7t5v0__fillcap_16$1
X_771_ _771_/D _771_/Q RSTN VSS _802_/CLK VDD VDD VSS gf180mcu_fd_sc_mcu7t5v0__dffrnq_1$1
Xu_adc.ckg.t\[3\].nxt.ch.g\[0\].d.u VDD u_adc.ckg.t\[2\].ug/A1 VSS u_adc.ckg.t\[3\].nxt.ch.g\[1\].d.u/I
+ VDD VSS gf180mcu_fd_sc_mcu7t5v0__dlyd_1$1
XFILLER_9_72 VDD VSS VDD VSS gf180mcu_fd_sc_mcu7t5v0__fillcap_8$1
X_754_ _754_/D _754_/Q RSTN VSS _802_/CLK VDD VDD VSS gf180mcu_fd_sc_mcu7t5v0__dffrnq_1$1
X_685_ _532_/B _685_/C VDD VSS _686_/A2 _691_/A1 _685_/A2 _685_/B1 VDD VSS gf180mcu_fd_sc_mcu7t5v0__aoi221_1$1
XFILLER_18_92 VDD VSS VDD VSS gf180mcu_fd_sc_mcu7t5v0__fillcap_4$1
X_470_ VDD VSS _476_/S _718_/Q _660_/A2 VDD VSS gf180mcu_fd_sc_mcu7t5v0__nand2_1$1
X_806_ VSS rst_sw[3] _806_/I VDD VDD VSS gf180mcu_fd_sc_mcu7t5v0__buf_2$1
X_668_ VDD VSS _673_/A2 _778_/Q _669_/A2 VDD VSS gf180mcu_fd_sc_mcu7t5v0__nor2_1$1
X_599_ VDD VSS _604_/B1 _755_/Q _692_/B VDD VSS gf180mcu_fd_sc_mcu7t5v0__nor2_1$1
X_737_ _737_/D _737_/Q RSTN VSS _802_/CLK VDD VDD VSS gf180mcu_fd_sc_mcu7t5v0__dffrnq_1$1
XFILLER_16_395 VDD VSS VDD VSS gf180mcu_fd_sc_mcu7t5v0__fillcap_4$1
Xu_tie_DIN_PU DIN_PU VDD VSS VDD VSS gf180mcu_fd_sc_mcu7t5v0__tiel$1
X_522_ _689_/A3 VDD VSS _522_/Z _738_/Q _684_/A2 VDD VSS gf180mcu_fd_sc_mcu7t5v0__or3_1$1
X_453_ VDD VSS _453_/ZN _793_/Q _795_/Q VDD VSS gf180mcu_fd_sc_mcu7t5v0__nand2_1$1
X_384_ VDD VSS _467_/A3 _728_/Q _727_/Q VDD VSS gf180mcu_fd_sc_mcu7t5v0__nor2_1$1
Xu_tie_CS_PD CS_PD VDD VSS VDD VSS gf180mcu_fd_sc_mcu7t5v0__tiel$1
XFILLER_14_107 VDD VSS VDD VSS gf180mcu_fd_sc_mcu7t5v0__fillcap_32$1
XFILLER_18_435 VDD VSS VDD VSS gf180mcu_fd_sc_mcu7t5v0__fillcap_4$1
XFILLER_18_457 VDD VSS VDD VSS gf180mcu_fd_sc_mcu7t5v0__fillcap_32$1
X_436_ VDD VSS dac_gp[3] _733_/Q _737_/Q VDD VSS gf180mcu_fd_sc_mcu7t5v0__nand2_1$1
X_505_ VDD VSS _506_/C1 _532_/B _499_/C VDD VSS gf180mcu_fd_sc_mcu7t5v0__nor2_1$1
X_367_ VDD VSS _560_/A1 _726_/Q _503_/A2 VDD VSS gf180mcu_fd_sc_mcu7t5v0__nor2_1$1
Xu_adc.ckg.t\[0\].first.ch.g\[2\].d.u VDD u_adc.ckg.t\[0\].first.ch.g\[2\].d.u/I VSS
+ u_adc.ckg.t\[0\].first.ch.g\[3\].d.u/I VDD VSS gf180mcu_fd_sc_mcu7t5v0__dlyd_1$1
X_419_ VDD VSS dac_gp[34] _761_/Q _773_/Q VDD VSS gf180mcu_fd_sc_mcu7t5v0__nand2_1$1
X_770_ _770_/D _770_/Q RSTN VSS _802_/CLK VDD VDD VSS gf180mcu_fd_sc_mcu7t5v0__dffrnq_1$1
XFILLER_15_224 VDD VSS VDD VSS gf180mcu_fd_sc_mcu7t5v0__fillcap_4$1
XFILLER_15_268 VDD VSS VDD VSS gf180mcu_fd_sc_mcu7t5v0__fillcap_4$1
XFILLER_11_474 VDD VSS VDD VSS gf180mcu_fd_sc_mcu7t5v0__fillcap_4$1
Xmax_cap1 VSS _692_/B _540_/S VDD VDD VSS gf180mcu_fd_sc_mcu7t5v0__buf_2$1
X_684_ _689_/A3 VDD VSS _684_/Z _783_/Q _684_/A2 VDD VSS gf180mcu_fd_sc_mcu7t5v0__or3_1$1
X_753_ _753_/D _753_/Q RSTN VSS _802_/CLK VDD VDD VSS gf180mcu_fd_sc_mcu7t5v0__dffrnq_1$1
XFILLER_16_511 VDD VSS VDD VSS gf180mcu_fd_sc_mcu7t5v0__fillcap_8$1
XFILLER_18_60 VDD VSS VDD VSS gf180mcu_fd_sc_mcu7t5v0__fillcap_32$1
XFILLER_7_220 VDD VSS VDD VSS gf180mcu_fd_sc_mcu7t5v0__fillcap_4$1
XFILLER_15_2 VDD VSS VDD VSS gf180mcu_fd_sc_mcu7t5v0__fillcap_8$1
XFILLER_14_18 VDD VSS VDD VSS gf180mcu_fd_sc_mcu7t5v0__fillcap_16$1
XFILLER_5_702 VDD VSS VDD VSS gf180mcu_fd_sc_mcu7t5v0__fillcap_16$1
Xsw\[0\].u_rec VDD VSS sw_rec[0] _453_/ZN VDD VSS gf180mcu_fd_sc_mcu7t5v0__clkinv_4$1
X_805_ VSS rst_sw[2] _805_/I VDD VDD VSS gf180mcu_fd_sc_mcu7t5v0__buf_2$1
XFILLER_0_495 VDD VSS VDD VSS gf180mcu_fd_sc_mcu7t5v0__fillcap_4$1
X_736_ _736_/D _736_/Q RSTN VSS _802_/CLK VDD VDD VSS gf180mcu_fd_sc_mcu7t5v0__dffrnq_1$1
X_667_ _667_/B _685_/C VDD VSS _777_/D _667_/A1 _667_/A2 VDD VSS gf180mcu_fd_sc_mcu7t5v0__aoi211_1$1
X_598_ _597_/Z VDD VSS _754_/D _601_/B _598_/A2 VDD VSS gf180mcu_fd_sc_mcu7t5v0__and3_1$1
X_383_ _543_/A3 VDD VSS _386_/B rst_amp_o _687_/A1 VDD VSS gf180mcu_fd_sc_mcu7t5v0__nand3_1$1
X_521_ VDD VSS _689_/A3 _533_/A2 _521_/A2 VDD VSS gf180mcu_fd_sc_mcu7t5v0__nor2_1$1
XFILLER_13_333 VDD VSS VDD VSS gf180mcu_fd_sc_mcu7t5v0__fillcap_8$1
X_452_ VDD VSS _452_/ZN _795_/Q _452_/A2 VDD VSS gf180mcu_fd_sc_mcu7t5v0__nand2_1$1
XFILLER_15_72 VDD VSS VDD VSS gf180mcu_fd_sc_mcu7t5v0__fillcap_64$1
X_719_ _719_/D _799_/D RSTN VSS _802_/CLK VDD VDD VSS gf180mcu_fd_sc_mcu7t5v0__dffrnq_1$1
XFILLER_16_193 VDD VSS VDD VSS gf180mcu_fd_sc_mcu7t5v0__fillcap_4$1
XFILLER_2_535 VDD VSS VDD VSS gf180mcu_fd_sc_mcu7t5v0__fillcap_4$1
X_435_ VDD VSS dac_gp[2] _733_/Q _736_/Q VDD VSS gf180mcu_fd_sc_mcu7t5v0__nand2_1$1
X_366_ VDD VSS _533_/A2 _481_/A1 _727_/Q VDD VSS gf180mcu_fd_sc_mcu7t5v0__nand2_1$1
X_504_ VDD VSS _678_/B1 _515_/A2 _687_/A2 VDD VSS gf180mcu_fd_sc_mcu7t5v0__nand2_1$1
XFILLER_13_185 VDD VSS VDD VSS gf180mcu_fd_sc_mcu7t5v0__fillcap_16$1
XFILLER_3_64 VDD VSS VDD VSS gf180mcu_fd_sc_mcu7t5v0__fillcap_4$1
Xu_adc.ckg.t\[2\].ui VSS u_adc.ckg.t\[2\].ui/ZN _789_/CLK VDD VDD VSS gf180mcu_fd_sc_mcu7t5v0__inv_1$1
XFILLER_10_122 VDD VSS VDD VSS gf180mcu_fd_sc_mcu7t5v0__fillcap_16$1
XFILLER_10_177 VDD VSS VDD VSS gf180mcu_fd_sc_mcu7t5v0__fillcap_4$1
Xsw\[3\].u_rec_b sw_rec_b[3] VSS VDD _445_/ZN VDD VSS gf180mcu_fd_sc_mcu7t5v0__clkbuf_8$1
X_418_ VDD VSS dac_gp[33] _761_/Q _771_/Q VDD VSS gf180mcu_fd_sc_mcu7t5v0__nand2_1$1
X_349_ VDD VSS dac_gn[5] _493_/A1 _739_/Q VDD VSS gf180mcu_fd_sc_mcu7t5v0__nor2_1$1
Xu_adc.ckg.t\[0\].first.ch.g\[1\].d.u VDD u_adc.ckg.t\[0\].first.ch.g\[1\].d.u/I VSS
+ u_adc.ckg.t\[0\].first.ch.g\[2\].d.u/I VDD VSS gf180mcu_fd_sc_mcu7t5v0__dlyd_1$1
XFILLER_19_597 VDD VSS VDD VSS gf180mcu_fd_sc_mcu7t5v0__fillcap_8$1
XFILLER_13_718 VDD VSS VDD VSS gf180mcu_fd_sc_mcu7t5v0__fillcap_8$1
X_752_ _752_/D _752_/Q RSTN VSS _802_/CLK VDD VDD VSS gf180mcu_fd_sc_mcu7t5v0__dffrnq_1$1
X_683_ _683_/B VDD VSS _782_/D _683_/A1 _685_/B1 VDD VSS gf180mcu_fd_sc_mcu7t5v0__aoi21_1$1
X_804_ VSS rst_sw[1] _804_/I VDD VDD VSS gf180mcu_fd_sc_mcu7t5v0__buf_3$1
X_735_ _735_/D _735_/Q RSTN VSS _802_/CLK VDD VDD VSS gf180mcu_fd_sc_mcu7t5v0__dffrnq_1$1
X_666_ _669_/A3 VDD VSS _667_/B _777_/Q _666_/A2 VDD VSS gf180mcu_fd_sc_mcu7t5v0__nor3_1$1
X_597_ _689_/A3 VDD VSS _597_/Z _753_/Q _689_/A2 VDD VSS gf180mcu_fd_sc_mcu7t5v0__or3_1$1
X_520_ VDD VSS _684_/A2 _689_/A2 _593_/A2 VDD VSS gf180mcu_fd_sc_mcu7t5v0__nand2_1$1
X_382_ VDD VSS _387_/A2 _728_/Q _481_/A2 VDD VSS gf180mcu_fd_sc_mcu7t5v0__nor2_1$1
X_451_ VDD VSS _451_/ZN _793_/Q _796_/Q VDD VSS gf180mcu_fd_sc_mcu7t5v0__nand2_1$1
X_718_ _718_/D _718_/Q RSTN VSS _802_/CLK VDD VDD VSS gf180mcu_fd_sc_mcu7t5v0__dffrnq_1$1
X_649_ VDD _656_/B _649_/A2 _650_/C _789_/Q VSS VDD VSS gf180mcu_fd_sc_mcu7t5v0__oai21_1$1
Xck.u_ckbuf VDD VSS _802_/CLK SCLK VDD VSS gf180mcu_fd_sc_mcu7t5v0__clkbuf_20$1
XFILLER_18_404 VDD VSS VDD VSS gf180mcu_fd_sc_mcu7t5v0__fillcap_4$1
X_503_ _543_/A1 VDD VSS _569_/A2 _726_/Q _503_/A2 VDD VSS gf180mcu_fd_sc_mcu7t5v0__nand3_1$1
X_434_ VDD VSS dac_gp[1] _733_/Q _735_/Q VDD VSS gf180mcu_fd_sc_mcu7t5v0__nand2_1$1
X_365_ VDD VSS _687_/A1 _728_/Q _542_/A2 VDD VSS gf180mcu_fd_sc_mcu7t5v0__nor2_1$1
XFILLER_13_142 VDD VSS VDD VSS gf180mcu_fd_sc_mcu7t5v0__fillcap_8$1
XFILLER_3_32 VDD VSS VDD VSS gf180mcu_fd_sc_mcu7t5v0__fillcap_32$1
Xu_adc.ckg.t\[2\].wch.g\[0\].d.u VDD u_adc.ckg.t\[2\].ug/A1 VSS u_adc.ckg.t\[2\].wch.g\[0\].d.u/Z
+ VDD VSS gf180mcu_fd_sc_mcu7t5v0__dlyd_1$1
XFILLER_15_407 VDD VSS VDD VSS gf180mcu_fd_sc_mcu7t5v0__fillcap_4$1
XFILLER_11_668 VDD VSS VDD VSS gf180mcu_fd_sc_mcu7t5v0__fillcap_32$1
XFILLER_5_2 VDD VSS VDD VSS gf180mcu_fd_sc_mcu7t5v0__fillcap_64$1
X_417_ VDD VSS dac_gp[32] _761_/Q _770_/Q VDD VSS gf180mcu_fd_sc_mcu7t5v0__nand2_1$1
X_348_ VDD VSS dac_gn[4] _493_/A1 _738_/Q VDD VSS gf180mcu_fd_sc_mcu7t5v0__nor2_1$1
XFILLER_5_193 VDD VSS VDD VSS gf180mcu_fd_sc_mcu7t5v0__fillcap_16$1
XFILLER_0_88 VDD VSS VDD VSS gf180mcu_fd_sc_mcu7t5v0__fillcap_4$1
X_682_ VDD _683_/B _682_/B _781_/Q _689_/A2 VSS _635_/S VDD VSS gf180mcu_fd_sc_mcu7t5v0__oai31_1$1
X_751_ _751_/D _751_/Q RSTN VSS _802_/CLK VDD VDD VSS gf180mcu_fd_sc_mcu7t5v0__dffrnq_1$1
Xu_adc.ckg.t\[0\].first.ch.g\[0\].d.u VDD _802_/CLK VSS u_adc.ckg.t\[0\].first.ch.g\[1\].d.u/I
+ VDD VSS gf180mcu_fd_sc_mcu7t5v0__dlyd_1$1
XFILLER_5_726 VDD VSS VDD VSS gf180mcu_fd_sc_mcu7t5v0__fillcap_4$1
X_665_ VDD VSS _667_/A2 _788_/Q _666_/A2 VDD VSS gf180mcu_fd_sc_mcu7t5v0__nand2_1$1
X_734_ _734_/D _734_/Q RSTN VSS _802_/CLK VDD VDD VSS gf180mcu_fd_sc_mcu7t5v0__dffrnq_1$1
X_803_ VSS rst_sw[0] _803_/I VDD VDD VSS gf180mcu_fd_sc_mcu7t5v0__buf_3$1
X_596_ _688_/B1 _602_/A2 VDD VSS _598_/A2 _609_/A1 _689_/A3 VDD VSS gf180mcu_fd_sc_mcu7t5v0__aoi22_1$1
XFILLER_16_387 VDD VSS VDD VSS gf180mcu_fd_sc_mcu7t5v0__fillcap_8$1
XFILLER_6_10 VDD VSS VDD VSS gf180mcu_fd_sc_mcu7t5v0__fillcap_4$1
X_450_ VDD VSS _450_/ZN _796_/Q _452_/A2 VDD VSS gf180mcu_fd_sc_mcu7t5v0__nand2_1$1
X_381_ VDD VSS _481_/A2 _727_/Q _379_/Z VDD VSS gf180mcu_fd_sc_mcu7t5v0__nand2_1$1
X_717_ _717_/D _717_/Q RSTN VSS _802_/CLK VDD VDD VSS gf180mcu_fd_sc_mcu7t5v0__dffrnq_1$1
X_648_ _651_/C VDD VSS _650_/B _532_/B _691_/A2 VDD VSS gf180mcu_fd_sc_mcu7t5v0__nor3_1$1
XFILLER_17_696 VDD VSS VDD VSS gf180mcu_fd_sc_mcu7t5v0__fillcap_4$1
X_579_ _499_/C _790_/Q _672_/B1 VDD VSS _580_/B _749_/Q _672_/A2 VDD VSS gf180mcu_fd_sc_mcu7t5v0__oai32_1$1
Xsw\[0\].u_ipg_b sw_ipg_b[0] VSS VDD _452_/ZN VDD VSS gf180mcu_fd_sc_mcu7t5v0__clkbuf_8$1
XFILLER_2_515 VDD VSS VDD VSS gf180mcu_fd_sc_mcu7t5v0__fillcap_4$1
X_433_ VDD VSS dac_gp[0] _733_/Q _734_/Q VDD VSS gf180mcu_fd_sc_mcu7t5v0__nand2_1$1
X_502_ _364_/Z VDD VSS _687_/A2 _502_/A1 _725_/Q VDD VSS gf180mcu_fd_sc_mcu7t5v0__nor3_1$1
X_364_ _731_/Q VDD VSS _364_/Z _729_/Q _730_/Q VDD VSS gf180mcu_fd_sc_mcu7t5v0__or3_1$1
XFILLER_9_114 VDD VSS VDD VSS gf180mcu_fd_sc_mcu7t5v0__fillcap_16$1
XFILLER_14_655 VDD VSS VDD VSS gf180mcu_fd_sc_mcu7t5v0__fillcap_8$1
X_416_ VDD VSS dac_gp[31] _761_/Q _769_/Q VDD VSS gf180mcu_fd_sc_mcu7t5v0__nand2_1$1
X_347_ VDD VSS dac_gn[3] _493_/A1 _737_/Q VDD VSS gf180mcu_fd_sc_mcu7t5v0__nor2_1$1
XFILLER_15_205 VDD VSS VDD VSS gf180mcu_fd_sc_mcu7t5v0__fillcap_4$1
XFILLER_0_56 VDD VSS VDD VSS gf180mcu_fd_sc_mcu7t5v0__fillcap_4$1
XFILLER_0_78 VDD VSS VDD VSS gf180mcu_fd_sc_mcu7t5v0__fillcap_4$1
X_681_ _685_/C VDD VSS _682_/B _691_/A1 _635_/S VDD VSS gf180mcu_fd_sc_mcu7t5v0__aoi21_1$1
X_750_ _750_/D _750_/Q RSTN VSS _802_/CLK VDD VDD VSS gf180mcu_fd_sc_mcu7t5v0__dffrnq_1$1
XFILLER_18_41 VDD VSS VDD VSS gf180mcu_fd_sc_mcu7t5v0__fillcap_8$1
XFILLER_7_212 VDD VSS VDD VSS gf180mcu_fd_sc_mcu7t5v0__fillcap_8$1
XFILLER_0_410 VDD VSS VDD VSS gf180mcu_fd_sc_mcu7t5v0__fillcap_4$1
X_802_ _802_/D hold3/I RSTN VSS _802_/CLK VDD VDD VSS gf180mcu_fd_sc_mcu7t5v0__dffrnq_1$1
XFILLER_4_259 VDD VSS VDD VSS gf180mcu_fd_sc_mcu7t5v0__fillcap_16$1
X_664_ VDD _664_/B _689_/A2 _667_/A1 _776_/Q VSS VDD VSS gf180mcu_fd_sc_mcu7t5v0__oai21_1$1
X_733_ _733_/D _733_/Q _775_/RN VSS _802_/CLK VDD VDD VSS gf180mcu_fd_sc_mcu7t5v0__dffrnq_1$1
X_595_ VDD VSS _602_/A2 _754_/Q _691_/A2 VDD VSS gf180mcu_fd_sc_mcu7t5v0__nor2_1$1
Xu_tie_DOUT_SL DOUT_SL VDD VSS VDD VSS gf180mcu_fd_sc_mcu7t5v0__tiel$1
Xu_tie_DOUT_PDRV0 DOUT_PDRV0 VDD VSS VDD VSS gf180mcu_fd_sc_mcu7t5v0__tiel$1
XFILLER_13_2 VDD VSS VDD VSS gf180mcu_fd_sc_mcu7t5v0__fillcap_8$1
XFILLER_19_193 VDD VSS VDD VSS gf180mcu_fd_sc_mcu7t5v0__fillcap_8$1
XFILLER_17_119 VDD VSS VDD VSS gf180mcu_fd_sc_mcu7t5v0__fillcap_8$1
X_380_ VDD VSS _615_/A1 _726_/Q _725_/Q VDD VSS gf180mcu_fd_sc_mcu7t5v0__nand2_1$1
Xu_adc.ckg.t\[2\].wch.g\[1\].genblk1.c.u _789_/CLK VSS u_adc.ckg.t\[2\].wch.g\[0\].d.u/Z
+ VDD VDD VSS gf180mcu_fd_sc_mcu7t5v0__dlyc_1$1
XFILLER_15_64 VDD VSS VDD VSS gf180mcu_fd_sc_mcu7t5v0__fillcap_4$1
XFILLER_0_240 VDD VSS VDD VSS gf180mcu_fd_sc_mcu7t5v0__fillcap_32$1
X_716_ _716_/D _716_/Q RSTN VSS _802_/CLK VDD VDD VSS gf180mcu_fd_sc_mcu7t5v0__dffrnq_1$1
X_647_ VDD VSS _651_/C _770_/Q _540_/S VDD VSS gf180mcu_fd_sc_mcu7t5v0__or2_1$2
X_578_ VDD VSS _748_/D _578_/A1 _578_/A2 VDD VSS gf180mcu_fd_sc_mcu7t5v0__nor2_1$1
XFILLER_16_163 VDD VSS VDD VSS gf180mcu_fd_sc_mcu7t5v0__fillcap_4$1
XFILLER_16_185 VDD VSS VDD VSS gf180mcu_fd_sc_mcu7t5v0__fillcap_8$1
.ends

.subckt bg_pfet__0 a_3550_0# a_838_0# a_5462_n60# a_2750_n60# a_7166_0# w_n180_n88#
+ a_4454_0# a_38_n60# a_4558_n60# a_n92_0# a_1742_0# a_1846_n60# a_5358_0# a_6366_n60#
+ a_6262_0# a_3654_n60# a_2646_0# a_942_n60#
X0 a_3550_0# a_2750_n60# a_2646_0# w_n180_n88# pfet_03v3 ad=2.6p pd=10.52u as=2.6p ps=10.52u w=10u l=4u
X1 a_6262_0# a_5462_n60# a_5358_0# w_n180_n88# pfet_03v3 ad=2.6p pd=10.52u as=2.6p ps=10.52u w=10u l=4u
X2 a_4454_0# a_3654_n60# a_3550_0# w_n180_n88# pfet_03v3 ad=2.6p pd=10.52u as=2.6p ps=10.52u w=10u l=4u
X3 a_7166_0# a_6366_n60# a_6262_0# w_n180_n88# pfet_03v3 ad=6.5p pd=21.3u as=2.6p ps=10.52u w=10u l=4u
X4 a_1742_0# a_942_n60# a_838_0# w_n180_n88# pfet_03v3 ad=2.6p pd=10.52u as=2.6p ps=10.52u w=10u l=4u
X5 a_838_0# a_38_n60# a_n92_0# w_n180_n88# pfet_03v3 ad=2.6p pd=10.52u as=6.5p ps=21.3u w=10u l=4u
X6 a_2646_0# a_1846_n60# a_1742_0# w_n180_n88# pfet_03v3 ad=2.6p pd=10.52u as=2.6p ps=10.52u w=10u l=4u
X7 a_5358_0# a_4558_n60# a_4454_0# w_n180_n88# pfet_03v3 ad=2.6p pd=10.52u as=2.6p ps=10.52u w=10u l=4u
.ends

.subckt bg_pg m1_6264_1718# m1_n500_1900# m1_4456_1718# w_n1060_n1060# m1_n84_n498#
+ m1_2648_1718# m1_840_1718#
Xbg_pfet__0_0 m1_n84_n498# m1_840_1718# m1_n500_1900# m1_n500_1900# m1_n84_n498# w_n1060_n1060#
+ m1_4456_1718# m1_n500_1900# m1_n500_1900# m1_n84_n498# m1_n84_n498# m1_n500_1900#
+ m1_n84_n498# m1_n500_1900# m1_6264_1718# m1_n500_1900# m1_2648_1718# m1_n500_1900#
+ bg_pfet__0
.ends

.subckt bg_nfet__5 a_8038_0# a_38_n60# a_n84_n10# VSUBS
X0 a_8038_0# a_38_n60# a_n84_n10# VSUBS nfet_03v3 ad=0.2128p pd=1.98u as=0.2128p ps=1.98u w=0.28u l=40u
.ends

.subckt bg_xsr bg_nfet__5_0/VSUBS m1_8080_n11# m1_150_186#
Xbg_nfet__5_0 m1_8080_n11# m1_150_186# bg_nfet__5_0/VSUBS bg_nfet__5_0/VSUBS bg_nfet__5
.ends

.subckt bg_xsr_rot bg_xsr_0/m1_150_186# bg_xsr_0/m1_8080_n11# VSUBS
Xbg_xsr_0 VSUBS bg_xsr_0/m1_8080_n11# bg_xsr_0/m1_150_186# bg_xsr
.ends

.subckt bg_pfet__3 a_838_0# w_n180_n88# a_38_n60# a_n92_0#
X0 a_838_0# a_38_n60# a_n92_0# w_n180_n88# pfet_03v3 ad=0.325p pd=2.3u as=0.325p ps=2.3u w=0.5u l=4u
.ends

.subckt bg_su m1_884_11# m1_3684_11# m1_2550_11# m1_2284_11# m1_1150_11# m1_1550_232#
+ w_n860_n660# m1_150_232# m1_2950_232#
Xbg_pfet__3_0 m1_3684_11# w_n860_n660# m1_2950_232# m1_2550_11# bg_pfet__3
Xbg_pfet__3_1 m1_2284_11# w_n860_n660# m1_1550_232# m1_1150_11# bg_pfet__3
Xbg_pfet__3_2 m1_884_11# w_n860_n660# m1_150_232# w_n860_n660# bg_pfet__3
.ends

.subckt bg_su_rot bg_su_0/m1_2550_11# bg_su_0/m1_3684_11# bg_su_0/m1_2284_11# bg_su_0/m1_1150_11#
+ bg_su_0/m1_1550_232# bg_su_0/m1_150_232# bg_su_0/w_n860_n660# bg_su_0/m1_2950_232#
+ bg_su_0/m1_884_11#
Xbg_su_0 bg_su_0/m1_884_11# bg_su_0/m1_3684_11# bg_su_0/m1_2550_11# bg_su_0/m1_2284_11#
+ bg_su_0/m1_1150_11# bg_su_0/m1_1550_232# bg_su_0/w_n860_n660# bg_su_0/m1_150_232#
+ bg_su_0/m1_2950_232# bg_su
.ends

.subckt bg_nfet__1 a_3550_0# a_838_0# a_2750_n60# a_4454_0# a_38_n60# a_1742_0# a_n84_0#
+ a_1846_n60# a_3654_n60# a_2646_0# a_942_n60# VSUBS
X0 a_3550_0# a_2750_n60# a_2646_0# VSUBS nfet_03v3 ad=3.328p pd=13.32u as=3.328p ps=13.32u w=12.8u l=4u
X1 a_4454_0# a_3654_n60# a_3550_0# VSUBS nfet_03v3 ad=7.808p pd=26.82u as=3.328p ps=13.32u w=12.8u l=4u
X2 a_1742_0# a_942_n60# a_838_0# VSUBS nfet_03v3 ad=3.328p pd=13.32u as=3.328p ps=13.32u w=12.8u l=4u
X3 a_838_0# a_38_n60# a_n84_0# VSUBS nfet_03v3 ad=3.328p pd=13.32u as=7.808p ps=26.82u w=12.8u l=4u
X4 a_2646_0# a_1846_n60# a_1742_0# VSUBS nfet_03v3 ad=3.328p pd=13.32u as=3.328p ps=13.32u w=12.8u l=4u
.ends

.subckt bg_n2 m1_840_2346# bg_nfet__1_0/VSUBS m1_n500_2500# m1_n80_n456#
Xbg_nfet__1_0 m1_n80_n456# m1_840_2346# m1_n500_2500# m1_840_2346# m1_n500_2500# m1_n80_n456#
+ m1_n80_n456# m1_n500_2500# m1_n500_2500# m1_840_2346# m1_n500_2500# bg_nfet__1_0/VSUBS
+ bg_nfet__1
.ends

.subckt bg_res_1_25 a_5000_0# a_n128_0# VSUBS
X0 a_n128_0# a_5000_0# VSUBS ppolyf_u_1k r_width=1u r_length=25u
.ends

.subckt bg_lad_b a_1072_8700# m1_17042_3150# a_6472_8700# m1_550_n50# m1_550_350#
+ m1_17042_7950# a_11872_8700# VSUBS
Xbg_res_1_25_0 m1_17042_7950# m1_11642_8350# VSUBS bg_res_1_25
Xbg_res_1_25_2 m1_6242_8350# m1_858_7550# VSUBS bg_res_1_25
Xbg_res_1_25_1 m1_11642_8350# m1_6242_8350# VSUBS bg_res_1_25
Xbg_res_1_25_3 m1_17042_7950# m1_11642_7950# VSUBS bg_res_1_25
Xbg_res_1_25_4 m1_11642_7950# m1_6242_7950# VSUBS bg_res_1_25
Xbg_res_1_25_5 m1_6242_7950# m1_1058_7150# VSUBS bg_res_1_25
Xbg_res_1_25_6 m1_17042_6750# m1_11642_7550# VSUBS bg_res_1_25
Xbg_res_1_25_7 m1_11642_7550# m1_6242_7550# VSUBS bg_res_1_25
Xbg_res_1_25_60 m1_17042_350# m1_11642_350# VSUBS bg_res_1_25
Xbg_res_1_25_8 m1_6242_7550# m1_858_7550# VSUBS bg_res_1_25
Xbg_res_1_25_61 m1_11642_350# m1_6242_350# VSUBS bg_res_1_25
Xbg_res_1_25_50 m1_6242_1950# m1_858_1150# VSUBS bg_res_1_25
Xbg_res_1_25_9 m1_17042_6350# m1_11642_7150# VSUBS bg_res_1_25
Xbg_res_1_25_62 m1_6242_350# m1_550_350# VSUBS bg_res_1_25
Xbg_res_1_25_51 m1_17042_1550# m1_11642_1550# VSUBS bg_res_1_25
Xbg_res_1_25_40 m1_11642_3150# m1_6242_3150# VSUBS bg_res_1_25
Xbg_res_1_25_63 m1_17042_n50# m1_11642_n50# VSUBS bg_res_1_25
Xbg_res_1_25_52 m1_11642_1550# m1_6242_1550# VSUBS bg_res_1_25
Xbg_res_1_25_41 m1_6242_3150# m1_1058_2350# VSUBS bg_res_1_25
Xbg_res_1_25_30 m1_17042_3550# m1_11642_4350# VSUBS bg_res_1_25
Xbg_res_1_25_64 m1_11642_n50# m1_6242_n50# VSUBS bg_res_1_25
Xbg_res_1_25_53 m1_6242_1550# m1_1058_750# VSUBS bg_res_1_25
Xbg_res_1_25_42 m1_17042_1950# m1_11642_2750# VSUBS bg_res_1_25
Xbg_res_1_25_31 m1_11642_4350# m1_6242_4350# VSUBS bg_res_1_25
Xbg_res_1_25_20 m1_6242_5950# m1_858_5950# VSUBS bg_res_1_25
Xbg_res_1_25_65 m1_6242_n50# m1_550_n50# VSUBS bg_res_1_25
Xbg_res_1_25_55 m1_11642_1150# m1_6242_1150# VSUBS bg_res_1_25
Xbg_res_1_25_54 m1_17042_350# m1_11642_1150# VSUBS bg_res_1_25
Xbg_res_1_25_44 m1_6242_2750# m1_858_2750# VSUBS bg_res_1_25
Xbg_res_1_25_43 m1_11642_2750# m1_6242_2750# VSUBS bg_res_1_25
Xbg_res_1_25_33 m1_17042_3150# m1_11642_3950# VSUBS bg_res_1_25
Xbg_res_1_25_32 m1_6242_4350# m1_858_4350# VSUBS bg_res_1_25
Xbg_res_1_25_22 m1_11642_5550# m1_6242_5550# VSUBS bg_res_1_25
Xbg_res_1_25_21 m1_17042_4750# m1_11642_5550# VSUBS bg_res_1_25
Xbg_res_1_25_11 m1_6242_7150# m1_1058_7150# VSUBS bg_res_1_25
Xbg_res_1_25_10 m1_11642_7150# m1_6242_7150# VSUBS bg_res_1_25
Xbg_res_1_25_56 m1_6242_1150# m1_858_1150# VSUBS bg_res_1_25
Xbg_res_1_25_45 m1_17042_1550# m1_11642_2350# VSUBS bg_res_1_25
Xbg_res_1_25_34 m1_11642_3950# m1_6242_3950# VSUBS bg_res_1_25
Xbg_res_1_25_23 m1_6242_5550# m1_1058_5550# VSUBS bg_res_1_25
Xbg_res_1_25_12 m1_17042_6750# m1_11642_6750# VSUBS bg_res_1_25
Xbg_res_1_25_57 m1_17042_n50# m1_11642_750# VSUBS bg_res_1_25
Xbg_res_1_25_46 m1_11642_2350# m1_6242_2350# VSUBS bg_res_1_25
Xbg_res_1_25_35 m1_6242_3950# m1_1058_3950# VSUBS bg_res_1_25
Xbg_res_1_25_24 m1_17042_5150# m1_11642_5150# VSUBS bg_res_1_25
Xbg_res_1_25_13 m1_11642_6750# m1_6242_6750# VSUBS bg_res_1_25
Xbg_res_1_25_58 m1_11642_750# m1_6242_750# VSUBS bg_res_1_25
Xbg_res_1_25_47 m1_6242_2350# m1_1058_2350# VSUBS bg_res_1_25
Xbg_res_1_25_36 m1_17042_3550# m1_11642_3550# VSUBS bg_res_1_25
Xbg_res_1_25_25 m1_11642_5150# m1_6242_5150# VSUBS bg_res_1_25
Xbg_res_1_25_14 m1_6242_6750# m1_858_5950# VSUBS bg_res_1_25
Xbg_res_1_25_59 m1_6242_750# m1_1058_750# VSUBS bg_res_1_25
Xbg_res_1_25_48 m1_17042_1950# m1_11642_1950# VSUBS bg_res_1_25
Xbg_res_1_25_37 m1_11642_3550# m1_6242_3550# VSUBS bg_res_1_25
Xbg_res_1_25_26 m1_6242_5150# m1_858_4350# VSUBS bg_res_1_25
Xbg_res_1_25_15 m1_17042_6350# m1_11642_6350# VSUBS bg_res_1_25
Xbg_res_1_25_49 m1_11642_1950# m1_6242_1950# VSUBS bg_res_1_25
Xbg_res_1_25_38 m1_6242_3550# m1_858_2750# VSUBS bg_res_1_25
Xbg_res_1_25_27 m1_17042_4750# m1_11642_4750# VSUBS bg_res_1_25
Xbg_res_1_25_16 m1_11642_6350# m1_6242_6350# VSUBS bg_res_1_25
Xbg_res_1_25_39 m1_17042_3150# m1_11642_3150# VSUBS bg_res_1_25
Xbg_res_1_25_28 m1_11642_4750# m1_6242_4750# VSUBS bg_res_1_25
Xbg_res_1_25_17 m1_6242_6350# m1_1058_5550# VSUBS bg_res_1_25
Xbg_res_1_25_29 m1_6242_4750# m1_1058_3950# VSUBS bg_res_1_25
Xbg_res_1_25_18 m1_17042_5150# m1_11642_5950# VSUBS bg_res_1_25
Xbg_res_1_25_19 m1_11642_5950# m1_6242_5950# VSUBS bg_res_1_25
.ends

.subckt bg_pfet__4 w_n180_n104# a_n92_n16# a_138_0# a_38_n136#
X0 a_138_0# a_38_n136# a_n92_n16# w_n180_n104# pfet_03v3 ad=0.2166p pd=2.06u as=0.2166p ps=2.06u w=0.22u l=0.5u
.ends

.subckt bg_rep m1_184_n450# m1_n50_n450# w_n20_n104#
Xbg_pfet__4_0 w_n20_n104# w_n20_n104# m1_184_n450# m1_n50_n450# bg_pfet__4
.ends

.subckt bg_rep_rot bg_rep_0/m1_184_n450# bg_rep_0/m1_n50_n450# bg_rep_0/w_n20_n104#
Xbg_rep_0 bg_rep_0/m1_184_n450# bg_rep_0/m1_n50_n450# bg_rep_0/w_n20_n104# bg_rep
.ends

.subckt bg_res_2_60 a_n128_0# a_12000_0# VSUBS
X0 a_n128_0# a_12000_0# VSUBS ppolyf_u_1k r_width=2u r_length=60u
.ends

.subckt bg_rb_res m1_150_750# m1_150_150# VSUBS
Xbg_res_2_60_0 m1_150_750# m1_12854_60# VSUBS bg_res_2_60
Xbg_res_2_60_1 m1_150_150# m1_12854_60# VSUBS bg_res_2_60
.ends

.subckt bg_rb_rot bg_rb_res_0/m1_150_750# bg_rb_res_0/m1_150_150# VSUBS
Xbg_rb_res_0 bg_rb_res_0/m1_150_750# bg_rb_res_0/m1_150_150# VSUBS bg_rb_res
.ends

.subckt bg_nfet__2 a_838_0# a_38_n60# a_1742_0# a_n84_0# a_942_n60# VSUBS
X0 a_1742_0# a_942_n60# a_838_0# VSUBS nfet_03v3 ad=4.88p pd=17.22u as=2.08p ps=8.52u w=8u l=4u
X1 a_838_0# a_38_n60# a_n84_0# VSUBS nfet_03v3 ad=2.08p pd=8.52u as=4.88p ps=17.22u w=8u l=4u
.ends

.subckt bg_n1 m1_n80_n496# m1_840_1316# m1_n500_1500# bg_nfet__2_0/VSUBS
Xbg_nfet__2_0 m1_840_1316# m1_n500_1500# m1_n80_n496# m1_n80_n496# m1_n500_1500# bg_nfet__2_0/VSUBS
+ bg_nfet__2
.ends

.subckt bg_cap_mim__6 m4_n120_n120# m4_0_0#
X0 m4_0_0# m4_n120_n120# cap_mim_2f0_m4m5_noshield c_width=49.885u c_length=49.885u
.ends

.subckt bg_cvrs m4_10480_680# m4_10077_100#
Xbg_cap_mim__6_0 m4_10077_100# m4_10480_680# bg_cap_mim__6
.ends

.subckt bg_lad_a m1_6242_7150# a_11872_n500# a_1072_n500# m1_550_n50# m1_550_350#
+ m1_17042_7950# a_6472_n500# VSUBS
Xbg_res_1_25_0 m1_17042_7950# m1_11642_8350# VSUBS bg_res_1_25
Xbg_res_1_25_2 m1_6242_8350# m1_858_7550# VSUBS bg_res_1_25
Xbg_res_1_25_1 m1_11642_8350# m1_6242_8350# VSUBS bg_res_1_25
Xbg_res_1_25_3 m1_17042_7950# m1_11642_7950# VSUBS bg_res_1_25
Xbg_res_1_25_4 m1_11642_7950# m1_6242_7950# VSUBS bg_res_1_25
Xbg_res_1_25_5 m1_6242_7950# m1_1058_7150# VSUBS bg_res_1_25
Xbg_res_1_25_6 m1_17042_6750# m1_11642_7550# VSUBS bg_res_1_25
Xbg_res_1_25_7 m1_11642_7550# m1_6242_7550# VSUBS bg_res_1_25
Xbg_res_1_25_60 m1_17042_350# m1_11642_350# VSUBS bg_res_1_25
Xbg_res_1_25_8 m1_6242_7550# m1_858_7550# VSUBS bg_res_1_25
Xbg_res_1_25_61 m1_11642_350# m1_6242_350# VSUBS bg_res_1_25
Xbg_res_1_25_50 m1_6242_1950# m1_858_1150# VSUBS bg_res_1_25
Xbg_res_1_25_9 m1_17042_6350# m1_11642_7150# VSUBS bg_res_1_25
Xbg_res_1_25_62 m1_6242_350# m1_550_350# VSUBS bg_res_1_25
Xbg_res_1_25_51 m1_17042_1550# m1_11642_1550# VSUBS bg_res_1_25
Xbg_res_1_25_40 m1_11642_3150# m1_6242_3150# VSUBS bg_res_1_25
Xbg_res_1_25_63 m1_17042_n50# m1_11642_n50# VSUBS bg_res_1_25
Xbg_res_1_25_52 m1_11642_1550# m1_6242_1550# VSUBS bg_res_1_25
Xbg_res_1_25_41 m1_6242_3150# m1_1058_2350# VSUBS bg_res_1_25
Xbg_res_1_25_30 m1_17042_3550# m1_11642_4350# VSUBS bg_res_1_25
Xbg_res_1_25_64 m1_11642_n50# m1_6242_n50# VSUBS bg_res_1_25
Xbg_res_1_25_53 m1_6242_1550# m1_1058_750# VSUBS bg_res_1_25
Xbg_res_1_25_42 m1_17042_1950# m1_11642_2750# VSUBS bg_res_1_25
Xbg_res_1_25_31 m1_11642_4350# m1_6242_4350# VSUBS bg_res_1_25
Xbg_res_1_25_20 m1_6242_5950# m1_858_5950# VSUBS bg_res_1_25
Xbg_res_1_25_65 m1_6242_n50# m1_550_n50# VSUBS bg_res_1_25
Xbg_res_1_25_55 m1_11642_1150# m1_6242_1150# VSUBS bg_res_1_25
Xbg_res_1_25_54 m1_17042_350# m1_11642_1150# VSUBS bg_res_1_25
Xbg_res_1_25_44 m1_6242_2750# m1_858_2750# VSUBS bg_res_1_25
Xbg_res_1_25_43 m1_11642_2750# m1_6242_2750# VSUBS bg_res_1_25
Xbg_res_1_25_33 m1_17042_3150# m1_11642_3950# VSUBS bg_res_1_25
Xbg_res_1_25_32 m1_6242_4350# m1_858_4350# VSUBS bg_res_1_25
Xbg_res_1_25_22 m1_11642_5550# m1_6242_5550# VSUBS bg_res_1_25
Xbg_res_1_25_21 m1_17042_4750# m1_11642_5550# VSUBS bg_res_1_25
Xbg_res_1_25_11 m1_6242_7150# m1_1058_7150# VSUBS bg_res_1_25
Xbg_res_1_25_10 m1_11642_7150# m1_6242_7150# VSUBS bg_res_1_25
Xbg_res_1_25_56 m1_6242_1150# m1_858_1150# VSUBS bg_res_1_25
Xbg_res_1_25_45 m1_17042_1550# m1_11642_2350# VSUBS bg_res_1_25
Xbg_res_1_25_34 m1_11642_3950# m1_6242_3950# VSUBS bg_res_1_25
Xbg_res_1_25_23 m1_6242_5550# m1_1058_5550# VSUBS bg_res_1_25
Xbg_res_1_25_12 m1_17042_6750# m1_11642_6750# VSUBS bg_res_1_25
Xbg_res_1_25_57 m1_17042_n50# m1_11642_750# VSUBS bg_res_1_25
Xbg_res_1_25_46 m1_11642_2350# m1_6242_2350# VSUBS bg_res_1_25
Xbg_res_1_25_35 m1_6242_3950# m1_1058_3950# VSUBS bg_res_1_25
Xbg_res_1_25_24 m1_17042_5150# m1_11642_5150# VSUBS bg_res_1_25
Xbg_res_1_25_13 m1_11642_6750# m1_6242_6750# VSUBS bg_res_1_25
Xbg_res_1_25_58 m1_11642_750# m1_6242_750# VSUBS bg_res_1_25
Xbg_res_1_25_47 m1_6242_2350# m1_1058_2350# VSUBS bg_res_1_25
Xbg_res_1_25_36 m1_17042_3550# m1_11642_3550# VSUBS bg_res_1_25
Xbg_res_1_25_25 m1_11642_5150# m1_6242_5150# VSUBS bg_res_1_25
Xbg_res_1_25_14 m1_6242_6750# m1_858_5950# VSUBS bg_res_1_25
Xbg_res_1_25_59 m1_6242_750# m1_1058_750# VSUBS bg_res_1_25
Xbg_res_1_25_48 m1_17042_1950# m1_11642_1950# VSUBS bg_res_1_25
Xbg_res_1_25_37 m1_11642_3550# m1_6242_3550# VSUBS bg_res_1_25
Xbg_res_1_25_26 m1_6242_5150# m1_858_4350# VSUBS bg_res_1_25
Xbg_res_1_25_15 m1_17042_6350# m1_11642_6350# VSUBS bg_res_1_25
Xbg_res_1_25_49 m1_11642_1950# m1_6242_1950# VSUBS bg_res_1_25
Xbg_res_1_25_38 m1_6242_3550# m1_858_2750# VSUBS bg_res_1_25
Xbg_res_1_25_27 m1_17042_4750# m1_11642_4750# VSUBS bg_res_1_25
Xbg_res_1_25_16 m1_11642_6350# m1_6242_6350# VSUBS bg_res_1_25
Xbg_res_1_25_39 m1_17042_3150# m1_11642_3150# VSUBS bg_res_1_25
Xbg_res_1_25_28 m1_11642_4750# m1_6242_4750# VSUBS bg_res_1_25
Xbg_res_1_25_17 m1_6242_6350# m1_1058_5550# VSUBS bg_res_1_25
Xbg_res_1_25_29 m1_6242_4750# m1_1058_3950# VSUBS bg_res_1_25
Xbg_res_1_25_18 m1_17042_5150# m1_11642_5950# VSUBS bg_res_1_25
Xbg_res_1_25_19 m1_11642_5950# m1_6242_5950# VSUBS bg_res_1_25
.ends

.subckt bias_genc vdd vcm_in vg1 vbn vcm_out vg2 vrs vss
Xbg_pg_0 m1_800_21870# m1_800_21870# vbn vdd vdd vbn m1_800_21870# bg_pg
Xbg_xsr_rot_0 vbn vrs vss bg_xsr_rot
Xbg_su_rot_0 m1_18600_12470# vbn m1_18600_12470# m1_18600_11070# m1_18600_12470# m1_18600_11070#
+ vdd vbn m1_18600_11070# bg_su_rot
Xbg_n2_0 m1_800_21870# vss vbn m1_13800_19270# bg_n2
Xbg_lad_b_0 bg_lad_b_0/a_1072_8700# vg2 bg_lad_b_0/a_6472_8700# vdd vss vcm_out bg_lad_b_0/a_11872_8700#
+ vss bg_lad_b
Xbg_rep_rot_0 vrs vrs vcm_in bg_rep_rot
Xbg_rb_rot_0 vss m1_13800_19270# vss bg_rb_rot
Xbg_n1_0 vss vbn vbn vss bg_n1
Xbg_cvrs_0 vrs vss bg_cvrs
Xbg_lad_a_0 vg1 bg_lad_b_0/a_11872_8700# bg_lad_b_0/a_1072_8700# vdd vss vcm_in bg_lad_b_0/a_6472_8700#
+ vss bg_lad_a
.ends

.subckt dbs_afe_top VDD REF E[0] REC[0] IPG[0] E[1] REC[1] IPG[1] E[2] REC[2] IPG[2]
+ E[3] REC[3] IPG[3] RSTN_PD RSTN_PU RSTN SCLK_PD SCLK_PU SCLK DIN_PD DIN_PU DIN CS_PD
+ CS_PU CS DOUT_OUT DOUT_OE DOUT_IE DOUT_PD DOUT_PU DOUT_CS DOUT_SL DOUT_PDRV0 DOUT_PDRV1
+ DOUT_IN VSS
Xcap_nmos_35 VDD VSS cap_nmos
Xcap_nmos_24 VDD VSS cap_nmos
Xcap_nmos_46 afe_ch_3/vdd_dac VSS cap_nmos
Xcap_nmos_57 afe_ch_3/vdd_dac VSS cap_nmos
Xcap_nmos_79 VDD VSS cap_nmos
Xcap_nmos_68 VDD VSS cap_nmos
Xcap_nmos_13 afe_ch_3/vdd_dac VSS cap_nmos
Xcap_nmos_36 VDD VSS cap_nmos
Xcap_nmos_25 VDD VSS cap_nmos
Xcap_nmos_47 afe_ch_3/vdd_dac VSS cap_nmos
Xcap_nmos_58 afe_ch_3/vdd_dac VSS cap_nmos
Xcap_nmos_69 VDD VSS cap_nmos
Xcap_nmos_14 afe_ch_3/vdd_dac VSS cap_nmos
Xcap_nmos_37 VDD VSS cap_nmos
Xcap_nmos_26 VDD VSS cap_nmos
Xcap_nmos_48 afe_ch_3/vdd_dac VSS cap_nmos
Xcap_nmos_59 afe_ch_3/vdd_dac VSS cap_nmos
Xcap_nmos_15 afe_ch_3/vdd_dac VSS cap_nmos
Xafe_ch_0 E[2] REC[2] IPG[2] REF afe_ch_3/vbn afe_ch_3/vcm afe_ch_3/vg1 afe_ch_3/vcmo
+ afe_ch_3/vg2 afe_ch_3/vrs afe_ch_0/sw_rec afe_ch_0/sw_rec_b afe_ch_0/sw_ipg afe_ch_0/sw_ipg_b
+ afe_ch_3/rst_amp afe_ch_0/rst_sw afe_ch_0/tg_on afe_ch_0/dac_gdn afe_ch_0/cmp_clk
+ afe_ch_0/cmp_q afe_ch_0/dac_gp[11] afe_ch_0/dac_gn[11] afe_ch_0/dac_gp[10] afe_ch_0/dac_gn[10]
+ afe_ch_0/dac_gp[9] afe_ch_0/dac_gn[9] afe_ch_0/dac_gp[8] afe_ch_0/dac_gn[8] afe_ch_0/dac_gp[7]
+ afe_ch_0/dac_gn[7] afe_ch_0/dac_gp[6] afe_ch_0/dac_gn[6] afe_ch_0/dac_gp[5] afe_ch_0/dac_gn[5]
+ afe_ch_0/dac_gp[4] afe_ch_0/dac_gn[4] afe_ch_0/dac_gp[3] afe_ch_0/dac_gn[3] afe_ch_0/dac_gp[2]
+ afe_ch_0/dac_gn[2] afe_ch_0/dac_gp[1] afe_ch_0/dac_gn[1] afe_ch_0/dac_gp[0] afe_ch_0/dac_gn[0]
+ VDD afe_ch_3/vdd_dac VDD VSS afe_ch
Xafe_dig_0 CS CS_PD CS_PU DIN DIN_PD DIN_PU DOUT_OUT DOUT_CS DOUT_IE DOUT_OE DOUT_PD
+ DOUT_PDRV0 DOUT_PDRV1 DOUT_PU DOUT_SL RSTN RSTN_PD RSTN_PU SCLK SCLK_PD SCLK_PU
+ afe_ch_3/rst_amp afe_ch_3/cmp_clk afe_ch_3/cmp_q afe_ch_3/dac_gdn afe_ch_3/dac_gn[0]
+ afe_ch_3/dac_gn[1] afe_ch_3/dac_gn[2] afe_ch_3/dac_gn[3] afe_ch_3/dac_gn[4] afe_ch_3/dac_gn[5]
+ afe_ch_3/dac_gn[6] afe_ch_3/dac_gn[7] afe_ch_3/dac_gn[8] afe_ch_3/dac_gn[9] afe_ch_3/dac_gn[10]
+ afe_ch_3/dac_gn[11] afe_ch_3/dac_gp[0] afe_ch_3/dac_gp[1] afe_ch_3/dac_gp[2] afe_ch_3/dac_gp[3]
+ afe_ch_3/dac_gp[4] afe_ch_3/dac_gp[5] afe_ch_3/dac_gp[6] afe_ch_3/dac_gp[7] afe_ch_3/dac_gp[8]
+ afe_ch_3/dac_gp[9] afe_ch_3/dac_gp[10] afe_ch_3/dac_gp[11] afe_ch_3/rst_sw afe_ch_3/sw_ipg
+ afe_ch_3/sw_ipg_b afe_ch_3/sw_rec afe_ch_3/sw_rec_b afe_ch_3/tg_on afe_ch_1/cmp_clk
+ afe_ch_1/dac_gdn afe_ch_1/dac_gn[1] afe_ch_1/cmp_q afe_ch_1/dac_gn[0] afe_ch_1/dac_gn[10]
+ afe_ch_1/dac_gn[11] afe_ch_1/dac_gn[2] afe_ch_1/dac_gp[1] afe_ch_1/dac_gn[3] afe_ch_1/dac_gn[4]
+ afe_ch_1/dac_gn[5] afe_ch_1/dac_gn[6] afe_ch_1/dac_gp[2] afe_ch_1/dac_gp[3] afe_ch_1/dac_gp[4]
+ afe_ch_1/dac_gp[5] afe_ch_1/dac_gp[6] afe_ch_1/dac_gp[7] afe_ch_1/dac_gp[8] afe_ch_1/dac_gp[9]
+ afe_ch_1/rst_sw afe_ch_1/dac_gn[7] afe_ch_1/sw_ipg afe_ch_1/dac_gn[8] afe_ch_1/sw_ipg_b
+ afe_ch_1/dac_gn[9] afe_ch_1/sw_rec afe_ch_1/dac_gp[0] afe_ch_1/sw_rec_b afe_ch_1/dac_gp[10]
+ afe_ch_1/tg_on afe_ch_1/dac_gp[11] afe_ch_0/dac_gp[5] afe_ch_0/cmp_q afe_ch_0/dac_gp[6]
+ afe_ch_0/dac_gp[7] afe_ch_0/dac_gp[8] afe_ch_0/dac_gp[9] afe_ch_0/dac_gp[10] afe_ch_0/dac_gp[11]
+ afe_ch_0/dac_gn[6] afe_ch_0/dac_gn[7] afe_ch_0/dac_gn[8] afe_ch_0/dac_gn[9] afe_ch_0/dac_gn[10]
+ afe_ch_0/dac_gn[11] afe_ch_0/dac_gdn afe_ch_0/cmp_clk afe_ch_0/dac_gn[0] afe_ch_0/rst_sw
+ afe_ch_0/dac_gn[1] afe_ch_0/dac_gn[2] afe_ch_0/sw_ipg afe_ch_0/dac_gn[3] afe_ch_0/dac_gn[4]
+ afe_ch_0/sw_ipg_b afe_ch_0/dac_gn[5] afe_ch_0/dac_gp[0] afe_ch_0/sw_rec afe_ch_0/dac_gp[1]
+ afe_ch_0/dac_gp[2] afe_ch_0/sw_rec_b afe_ch_0/dac_gp[3] afe_ch_0/dac_gp[4] afe_ch_0/tg_on
+ afe_ch_2/dac_gp[9] afe_ch_2/dac_gp[10] afe_ch_2/dac_gp[11] afe_ch_2/dac_gdn afe_ch_2/dac_gn[4]
+ afe_ch_2/dac_gn[5] afe_ch_2/dac_gn[6] afe_ch_2/dac_gn[7] afe_ch_2/dac_gn[8] afe_ch_2/dac_gn[9]
+ afe_ch_2/dac_gn[10] afe_ch_2/dac_gn[11] afe_ch_2/rst_sw afe_ch_2/cmp_q afe_ch_2/cmp_clk
+ afe_ch_2/dac_gn[0] afe_ch_2/sw_ipg afe_ch_2/dac_gn[1] afe_ch_2/dac_gn[2] afe_ch_2/dac_gp[0]
+ afe_ch_2/sw_ipg_b afe_ch_2/dac_gp[1] afe_ch_2/dac_gp[2] afe_ch_2/dac_gp[3] afe_ch_2/sw_rec
+ afe_ch_2/dac_gn[3] afe_ch_2/dac_gp[4] afe_ch_2/dac_gp[5] afe_ch_2/sw_rec_b afe_ch_2/dac_gp[6]
+ afe_ch_2/dac_gp[7] afe_ch_2/dac_gp[8] afe_ch_2/tg_on VDD VSS afe_dig
Xcap_nmos_38 VDD VSS cap_nmos
Xcap_nmos_27 VDD VSS cap_nmos
Xcap_nmos_16 VDD VSS cap_nmos
Xcap_nmos_49 afe_ch_3/vdd_dac VSS cap_nmos
Xafe_ch_1 E[0] REC[0] IPG[0] REF afe_ch_3/vbn afe_ch_3/vcm afe_ch_3/vg1 afe_ch_3/vcmo
+ afe_ch_3/vg2 afe_ch_3/vrs afe_ch_1/sw_rec afe_ch_1/sw_rec_b afe_ch_1/sw_ipg afe_ch_1/sw_ipg_b
+ afe_ch_3/rst_amp afe_ch_1/rst_sw afe_ch_1/tg_on afe_ch_1/dac_gdn afe_ch_1/cmp_clk
+ afe_ch_1/cmp_q afe_ch_1/dac_gp[11] afe_ch_1/dac_gn[11] afe_ch_1/dac_gp[10] afe_ch_1/dac_gn[10]
+ afe_ch_1/dac_gp[9] afe_ch_1/dac_gn[9] afe_ch_1/dac_gp[8] afe_ch_1/dac_gn[8] afe_ch_1/dac_gp[7]
+ afe_ch_1/dac_gn[7] afe_ch_1/dac_gp[6] afe_ch_1/dac_gn[6] afe_ch_1/dac_gp[5] afe_ch_1/dac_gn[5]
+ afe_ch_1/dac_gp[4] afe_ch_1/dac_gn[4] afe_ch_1/dac_gp[3] afe_ch_1/dac_gn[3] afe_ch_1/dac_gp[2]
+ afe_ch_1/dac_gn[2] afe_ch_1/dac_gp[1] afe_ch_1/dac_gn[1] afe_ch_1/dac_gp[0] afe_ch_1/dac_gn[0]
+ VDD afe_ch_3/vdd_dac VDD VSS afe_ch
Xcap_nmos_39 VDD VSS cap_nmos
Xcap_nmos_28 VDD VSS cap_nmos
Xcap_nmos_17 afe_ch_3/vdd_dac VSS cap_nmos
Xafe_ch_2 E[3] REC[3] IPG[3] REF afe_ch_3/vbn afe_ch_3/vcm afe_ch_3/vg1 afe_ch_3/vcmo
+ afe_ch_3/vg2 afe_ch_3/vrs afe_ch_2/sw_rec afe_ch_2/sw_rec_b afe_ch_2/sw_ipg afe_ch_2/sw_ipg_b
+ afe_ch_3/rst_amp afe_ch_2/rst_sw afe_ch_2/tg_on afe_ch_2/dac_gdn afe_ch_2/cmp_clk
+ afe_ch_2/cmp_q afe_ch_2/dac_gp[11] afe_ch_2/dac_gn[11] afe_ch_2/dac_gp[10] afe_ch_2/dac_gn[10]
+ afe_ch_2/dac_gp[9] afe_ch_2/dac_gn[9] afe_ch_2/dac_gp[8] afe_ch_2/dac_gn[8] afe_ch_2/dac_gp[7]
+ afe_ch_2/dac_gn[7] afe_ch_2/dac_gp[6] afe_ch_2/dac_gn[6] afe_ch_2/dac_gp[5] afe_ch_2/dac_gn[5]
+ afe_ch_2/dac_gp[4] afe_ch_2/dac_gn[4] afe_ch_2/dac_gp[3] afe_ch_2/dac_gn[3] afe_ch_2/dac_gp[2]
+ afe_ch_2/dac_gn[2] afe_ch_2/dac_gp[1] afe_ch_2/dac_gn[1] afe_ch_2/dac_gp[0] afe_ch_2/dac_gn[0]
+ VDD afe_ch_3/vdd_dac VDD VSS afe_ch
Xcap_nmos_29 VDD VSS cap_nmos
Xcap_nmos_18 afe_ch_3/vdd_dac VSS cap_nmos
Xafe_ch_3 E[1] REC[1] IPG[1] REF afe_ch_3/vbn afe_ch_3/vcm afe_ch_3/vg1 afe_ch_3/vcmo
+ afe_ch_3/vg2 afe_ch_3/vrs afe_ch_3/sw_rec afe_ch_3/sw_rec_b afe_ch_3/sw_ipg afe_ch_3/sw_ipg_b
+ afe_ch_3/rst_amp afe_ch_3/rst_sw afe_ch_3/tg_on afe_ch_3/dac_gdn afe_ch_3/cmp_clk
+ afe_ch_3/cmp_q afe_ch_3/dac_gp[11] afe_ch_3/dac_gn[11] afe_ch_3/dac_gp[10] afe_ch_3/dac_gn[10]
+ afe_ch_3/dac_gp[9] afe_ch_3/dac_gn[9] afe_ch_3/dac_gp[8] afe_ch_3/dac_gn[8] afe_ch_3/dac_gp[7]
+ afe_ch_3/dac_gn[7] afe_ch_3/dac_gp[6] afe_ch_3/dac_gn[6] afe_ch_3/dac_gp[5] afe_ch_3/dac_gn[5]
+ afe_ch_3/dac_gp[4] afe_ch_3/dac_gn[4] afe_ch_3/dac_gp[3] afe_ch_3/dac_gn[3] afe_ch_3/dac_gp[2]
+ afe_ch_3/dac_gn[2] afe_ch_3/dac_gp[1] afe_ch_3/dac_gn[1] afe_ch_3/dac_gp[0] afe_ch_3/dac_gn[0]
+ VDD afe_ch_3/vdd_dac VDD VSS afe_ch
Xcap_nmos_19 afe_ch_3/vdd_dac VSS cap_nmos
Xcap_nmos_100 afe_ch_3/vdd_dac VSS cap_nmos
Xcap_nmos_101 VDD VSS cap_nmos
Xcap_nmos_102 afe_ch_3/vdd_dac VSS cap_nmos
Xbias_genc_0 VDD afe_ch_3/vcm afe_ch_3/vg1 afe_ch_3/vbn afe_ch_3/vcmo afe_ch_3/vg2
+ afe_ch_3/vrs VSS bias_genc
Xcap_nmos_103 afe_ch_3/vdd_dac VSS cap_nmos
Xcap_nmos_0 VDD VSS cap_nmos
Xcap_nmos_1 VDD VSS cap_nmos
Xcap_nmos_2 VDD VSS cap_nmos
Xcap_nmos_3 VDD VSS cap_nmos
Xcap_nmos_4 VDD VSS cap_nmos
Xcap_nmos_90 VDD VSS cap_nmos
Xcap_nmos_5 VDD VSS cap_nmos
Xcap_nmos_91 VDD VSS cap_nmos
Xcap_nmos_80 VDD VSS cap_nmos
Xcap_nmos_6 VDD VSS cap_nmos
Xcap_nmos_92 VDD VSS cap_nmos
Xcap_nmos_81 VDD VSS cap_nmos
Xcap_nmos_70 VDD VSS cap_nmos
Xcap_nmos_7 VDD VSS cap_nmos
Xcap_nmos_93 VDD VSS cap_nmos
Xcap_nmos_82 VDD VSS cap_nmos
Xcap_nmos_60 afe_ch_3/vdd_dac VSS cap_nmos
Xcap_nmos_71 VDD VSS cap_nmos
Xcap_nmos_8 VDD VSS cap_nmos
Xcap_nmos_94 VDD VSS cap_nmos
Xcap_nmos_50 afe_ch_3/vdd_dac VSS cap_nmos
Xcap_nmos_83 VDD VSS cap_nmos
Xcap_nmos_61 afe_ch_3/vdd_dac VSS cap_nmos
Xcap_nmos_72 VDD VSS cap_nmos
Xcap_nmos_9 VDD VSS cap_nmos
Xcap_nmos_84 VDD VSS cap_nmos
Xcap_nmos_40 VDD VSS cap_nmos
Xcap_nmos_51 afe_ch_3/vdd_dac VSS cap_nmos
Xcap_nmos_62 VDD VSS cap_nmos
Xcap_nmos_73 VDD VSS cap_nmos
Xcap_nmos_95 VDD VSS cap_nmos
Xcap_nmos_41 VDD VSS cap_nmos
Xcap_nmos_30 VDD VSS cap_nmos
Xcap_nmos_52 afe_ch_3/vdd_dac VSS cap_nmos
Xcap_nmos_85 VDD VSS cap_nmos
Xcap_nmos_63 VDD VSS cap_nmos
Xcap_nmos_74 VDD VSS cap_nmos
Xcap_nmos_96 afe_ch_3/vdd_dac VSS cap_nmos
Xcap_nmos_86 VDD VSS cap_nmos
Xcap_nmos_42 VDD VSS cap_nmos
Xcap_nmos_31 VDD VSS cap_nmos
Xcap_nmos_20 afe_ch_3/vdd_dac VSS cap_nmos
Xcap_nmos_53 afe_ch_3/vdd_dac VSS cap_nmos
Xcap_nmos_64 VDD VSS cap_nmos
Xcap_nmos_75 VDD VSS cap_nmos
Xcap_nmos_97 afe_ch_3/vdd_dac VSS cap_nmos
Xcap_nmos_87 VDD VSS cap_nmos
Xcap_nmos_43 VDD VSS cap_nmos
Xcap_nmos_32 VDD VSS cap_nmos
Xcap_nmos_10 VDD VSS cap_nmos
Xcap_nmos_21 VDD VSS cap_nmos
Xcap_nmos_54 afe_ch_3/vdd_dac VSS cap_nmos
Xcap_nmos_65 VDD VSS cap_nmos
Xcap_nmos_76 VDD VSS cap_nmos
Xcap_nmos_98 VDD VSS cap_nmos
Xcap_nmos_66 VDD VSS cap_nmos
Xcap_nmos_88 VDD VSS cap_nmos
Xcap_nmos_33 VDD VSS cap_nmos
Xcap_nmos_22 VDD VSS cap_nmos
Xcap_nmos_44 afe_ch_3/vdd_dac VSS cap_nmos
Xcap_nmos_55 afe_ch_3/vdd_dac VSS cap_nmos
Xcap_nmos_77 VDD VSS cap_nmos
Xcap_nmos_99 VDD VSS cap_nmos
Xcap_nmos_11 VDD VSS cap_nmos
Xcap_nmos_67 VDD VSS cap_nmos
Xcap_nmos_89 VDD VSS cap_nmos
Xcap_nmos_34 VDD VSS cap_nmos
Xcap_nmos_23 VDD VSS cap_nmos
Xcap_nmos_45 afe_ch_3/vdd_dac VSS cap_nmos
Xcap_nmos_56 afe_ch_3/vdd_dac VSS cap_nmos
Xcap_nmos_78 VDD VSS cap_nmos
Xcap_nmos_12 VDD VSS cap_nmos
X0 VDD afe_ch_3/vdd_dac rm3 r_width=2u r_length=0.2222m
.ends
