* NGSPICE file created from adc_ch.ext - technology: gf180mcuD

.subckt pfet__1 a_28_460# w_n180_n88# a_n92_0# a_94_0#
X0 a_94_0# a_28_460# a_n92_0# w_n180_n88# pfet_03v3 ad=1.3p pd=5.3u as=1.3p ps=5.3u w=2u l=0.28u
.ends

.subckt sw_p m1_n250_60# m1_140_60# m1_n50_950# w_n1060_n860#
Xpfet__1_0 m1_n50_950# w_n1060_n860# m1_n250_60# m1_140_60# pfet__1
.ends

.subckt cap_mim__2 m4_n120_n120# m4_0_0#
X0 m4_0_0# m4_n120_n120# cap_mim_2f0_m4m5_noshield c_width=5u c_length=5u
.ends

.subckt cap_mim__3 m4_n120_n120# m4_0_0#
X0 m4_0_0# m4_n120_n120# cap_mim_2f0_m4m5_noshield c_width=5.085u c_length=5u
.ends

.subckt dac m4_12080_16680# m4_13680_16680# m4_24659_21700# m5_14720_17800# m4_24659_11300#
+ m4_2880_13880# m4_24280_16680# m4_7280_16680# m4_20280_16680# m4_3880_9440# m4_21880_16680#
+ m4_9480_16680# m4_5480_16680# m4_24659_19100# m5_3540_11640# m4_11280_16680# m4_4280_16680#
+ m4_5880_16680# m4_18080_16680# m4_22880_16680# m4_2880_21680# m4_2880_11280# m4_16280_16680#
+ m4_24659_13900# m4_2880_19080# m4_16680_16680# m4_3880_22920#
Xcap_mim__2_96 m4_24659_21700# m5_14720_17800# cap_mim__2
Xcap_mim__2_30 m4_24659_11300# m5_14720_17800# cap_mim__2
Xcap_mim__2_41 m4_2880_13880# m5_3540_11640# cap_mim__2
Xcap_mim__2_52 m4_2880_11280# m5_3540_11640# cap_mim__2
Xcap_mim__2_63 m4_2880_11280# m5_3540_11640# cap_mim__2
Xcap_mim__2_74 m4_2880_21680# m5_3540_11640# cap_mim__2
Xcap_mim__2_85 m4_2880_19080# m5_3540_11640# cap_mim__2
Xcap_mim__2_97 m4_24659_21700# m5_14720_17800# cap_mim__2
Xcap_mim__2_20 m4_24659_11300# m5_14720_17800# cap_mim__2
Xcap_mim__2_31 m4_24659_11300# m5_14720_17800# cap_mim__2
Xcap_mim__2_42 m4_2880_13880# m5_3540_11640# cap_mim__2
Xcap_mim__2_53 m4_2880_11280# m5_3540_11640# cap_mim__2
Xcap_mim__2_64 m4_2880_21680# m5_3540_11640# cap_mim__2
Xcap_mim__2_75 m4_2880_21680# m5_3540_11640# cap_mim__2
Xcap_mim__2_86 m4_2880_19080# m5_3540_11640# cap_mim__2
Xcap_mim__2_98 m4_24659_21700# m5_14720_17800# cap_mim__2
Xcap_mim__2_10 m4_24659_13900# m5_14720_17800# cap_mim__2
Xcap_mim__2_21 m4_24659_11300# m5_14720_17800# cap_mim__2
Xcap_mim__2_32 m4_11280_16680# m5_3540_11640# cap_mim__2
Xcap_mim__2_43 m4_2880_13880# m5_3540_11640# cap_mim__2
Xcap_mim__2_54 m4_2880_11280# m5_3540_11640# cap_mim__2
Xcap_mim__2_65 m4_2880_21680# m5_3540_11640# cap_mim__2
Xcap_mim__2_76 m4_2880_21680# m5_3540_11640# cap_mim__2
Xcap_mim__2_87 m4_2880_19080# m5_3540_11640# cap_mim__2
Xcap_mim__2_99 m4_24659_21700# m5_14720_17800# cap_mim__2
Xcap_mim__2_11 m4_24659_13900# m5_14720_17800# cap_mim__2
Xcap_mim__2_22 m4_24659_11300# m5_14720_17800# cap_mim__2
Xcap_mim__2_33 m4_11280_16680# m5_3540_11640# cap_mim__2
Xcap_mim__2_44 m4_2880_13880# m5_3540_11640# cap_mim__2
Xcap_mim__2_55 m4_2880_11280# m5_3540_11640# cap_mim__2
Xcap_mim__2_66 m4_2880_21680# m5_3540_11640# cap_mim__2
Xcap_mim__2_77 m4_2880_21680# m5_3540_11640# cap_mim__2
Xcap_mim__2_88 m4_13680_16680# m5_3540_11640# cap_mim__2
Xcap_mim__2_12 m4_24659_13900# m5_14720_17800# cap_mim__2
Xcap_mim__2_23 m4_24659_11300# m5_14720_17800# cap_mim__2
Xcap_mim__2_34 m4_11280_16680# m5_3540_11640# cap_mim__2
Xcap_mim__2_45 m4_2880_13880# m5_3540_11640# cap_mim__2
Xcap_mim__2_56 m4_2880_11280# m5_3540_11640# cap_mim__2
Xcap_mim__2_67 m4_2880_21680# m5_3540_11640# cap_mim__2
Xcap_mim__2_78 m4_2880_21680# m5_3540_11640# cap_mim__2
Xcap_mim__2_89 m4_12080_16680# m5_3540_11640# cap_mim__2
Xcap_mim__2_13 m4_24659_13900# m5_14720_17800# cap_mim__2
Xcap_mim__2_24 m4_24659_11300# m5_14720_17800# cap_mim__2
Xcap_mim__2_35 m4_11280_16680# m5_3540_11640# cap_mim__2
Xcap_mim__2_46 m4_2880_13880# m5_3540_11640# cap_mim__2
Xcap_mim__2_57 m4_2880_11280# m5_3540_11640# cap_mim__2
Xcap_mim__2_68 m4_2880_21680# m5_3540_11640# cap_mim__2
Xcap_mim__2_79 m4_2880_21680# m5_3540_11640# cap_mim__2
Xcap_mim__2_120 m4_21880_16680# m5_14720_17800# cap_mim__2
Xcap_mim__2_14 m4_24659_13900# m5_14720_17800# cap_mim__2
Xcap_mim__2_25 m4_24659_11300# m5_14720_17800# cap_mim__2
Xcap_mim__2_36 m4_7280_16680# m5_3540_11640# cap_mim__2
Xcap_mim__2_47 m4_2880_13880# m5_3540_11640# cap_mim__2
Xcap_mim__2_58 m4_2880_11280# m5_3540_11640# cap_mim__2
Xcap_mim__2_69 m4_2880_21680# m5_3540_11640# cap_mim__2
Xcap_mim__2_121 m4_21880_16680# m5_14720_17800# cap_mim__2
Xcap_mim__2_110 m4_24659_21700# m5_14720_17800# cap_mim__2
Xcap_mim__2_15 m4_24659_13900# m5_14720_17800# cap_mim__2
Xcap_mim__2_26 m4_24659_11300# m5_14720_17800# cap_mim__2
Xcap_mim__2_37 m4_7280_16680# m5_3540_11640# cap_mim__2
Xcap_mim__2_48 m4_2880_11280# m5_3540_11640# cap_mim__2
Xcap_mim__2_59 m4_2880_11280# m5_3540_11640# cap_mim__2
Xcap_mim__2_122 m4_21880_16680# m5_14720_17800# cap_mim__2
Xcap_mim__2_111 m4_24659_21700# m5_14720_17800# cap_mim__2
Xcap_mim__2_100 m4_24659_21700# m5_14720_17800# cap_mim__2
Xcap_mim__2_16 m4_24659_11300# m5_14720_17800# cap_mim__2
Xcap_mim__2_27 m4_24659_11300# m5_14720_17800# cap_mim__2
Xcap_mim__2_38 m4_5880_16680# m5_3540_11640# cap_mim__2
Xcap_mim__2_49 m4_2880_11280# m5_3540_11640# cap_mim__2
Xcap_mim__2_123 m4_21880_16680# m5_14720_17800# cap_mim__2
Xcap_mim__2_112 m4_24659_19100# m5_14720_17800# cap_mim__2
Xcap_mim__2_101 m4_24659_21700# m5_14720_17800# cap_mim__2
Xcap_mim__2_17 m4_24659_11300# m5_14720_17800# cap_mim__2
Xcap_mim__2_28 m4_24659_11300# m5_14720_17800# cap_mim__2
Xcap_mim__2_39 m4_4280_16680# m5_3540_11640# cap_mim__2
Xcap_mim__2_124 m4_18080_16680# m5_14720_17800# cap_mim__2
Xcap_mim__2_113 m4_24659_19100# m5_14720_17800# cap_mim__2
Xcap_mim__2_102 m4_24659_21700# m5_14720_17800# cap_mim__2
Xcap_mim__2_0 m4_24280_16680# m5_14720_17800# cap_mim__2
Xcap_mim__2_18 m4_24659_11300# m5_14720_17800# cap_mim__2
Xcap_mim__2_29 m4_24659_11300# m5_14720_17800# cap_mim__2
Xcap_mim__2_125 m4_18080_16680# m5_14720_17800# cap_mim__2
Xcap_mim__2_114 m4_24659_19100# m5_14720_17800# cap_mim__2
Xcap_mim__2_103 m4_24659_21700# m5_14720_17800# cap_mim__2
Xcap_mim__2_1 m4_22880_16680# m5_14720_17800# cap_mim__2
Xcap_mim__2_19 m4_24659_11300# m5_14720_17800# cap_mim__2
Xcap_mim__2_126 m4_16680_16680# m5_14720_17800# cap_mim__2
Xcap_mim__2_115 m4_24659_19100# m5_14720_17800# cap_mim__2
Xcap_mim__2_104 m4_24659_21700# m5_14720_17800# cap_mim__2
Xcap_mim__2_2 m4_20280_16680# m5_14720_17800# cap_mim__2
Xcap_mim__2_116 m4_24659_19100# m5_14720_17800# cap_mim__2
Xcap_mim__2_105 m4_24659_21700# m5_14720_17800# cap_mim__2
Xcap_mim__2_3 m4_20280_16680# m5_14720_17800# cap_mim__2
Xcap_mim__2_117 m4_24659_19100# m5_14720_17800# cap_mim__2
Xcap_mim__2_106 m4_24659_21700# m5_14720_17800# cap_mim__2
Xcap_mim__2_4 m4_16280_16680# m5_14720_17800# cap_mim__2
Xcap_mim__2_118 m4_24659_19100# m5_14720_17800# cap_mim__2
Xcap_mim__2_107 m4_24659_21700# m5_14720_17800# cap_mim__2
Xcap_mim__2_5 m4_16280_16680# m5_14720_17800# cap_mim__2
Xcap_mim__2_119 m4_24659_19100# m5_14720_17800# cap_mim__2
Xcap_mim__2_108 m4_24659_21700# m5_14720_17800# cap_mim__2
Xcap_mim__2_6 m4_16280_16680# m5_14720_17800# cap_mim__2
Xcap_mim__2_109 m4_24659_21700# m5_14720_17800# cap_mim__2
Xcap_mim__2_7 m4_16280_16680# m5_14720_17800# cap_mim__2
Xcap_mim__2_8 m4_24659_13900# m5_14720_17800# cap_mim__2
Xcap_mim__2_9 m4_24659_13900# m5_14720_17800# cap_mim__2
Xcap_mim__3_0 m5_3540_11640# m5_14720_17800# cap_mim__3
Xcap_mim__2_90 m4_9480_16680# m5_3540_11640# cap_mim__2
Xcap_mim__2_80 m4_2880_19080# m5_3540_11640# cap_mim__2
Xcap_mim__2_91 m4_9480_16680# m5_3540_11640# cap_mim__2
Xcap_mim__2_70 m4_2880_21680# m5_3540_11640# cap_mim__2
Xcap_mim__2_81 m4_2880_19080# m5_3540_11640# cap_mim__2
Xcap_mim__2_92 m4_5480_16680# m5_3540_11640# cap_mim__2
Xcap_mim__2_60 m4_2880_11280# m5_3540_11640# cap_mim__2
Xcap_mim__2_71 m4_2880_21680# m5_3540_11640# cap_mim__2
Xcap_mim__2_82 m4_2880_19080# m5_3540_11640# cap_mim__2
Xcap_mim__2_93 m4_5480_16680# m5_3540_11640# cap_mim__2
Xcap_mim__2_50 m4_2880_11280# m5_3540_11640# cap_mim__2
Xcap_mim__2_61 m4_2880_11280# m5_3540_11640# cap_mim__2
Xcap_mim__2_72 m4_2880_21680# m5_3540_11640# cap_mim__2
Xcap_mim__2_83 m4_2880_19080# m5_3540_11640# cap_mim__2
Xcap_mim__2_94 m4_5480_16680# m5_3540_11640# cap_mim__2
Xcap_mim__2_40 m4_2880_13880# m5_3540_11640# cap_mim__2
Xcap_mim__2_51 m4_2880_11280# m5_3540_11640# cap_mim__2
Xcap_mim__2_62 m4_2880_11280# m5_3540_11640# cap_mim__2
Xcap_mim__2_73 m4_2880_21680# m5_3540_11640# cap_mim__2
Xcap_mim__2_84 m4_2880_19080# m5_3540_11640# cap_mim__2
Xcap_mim__2_95 m4_5480_16680# m5_3540_11640# cap_mim__2
.ends

.subckt nfet__0 a_30_260# a_n84_0# a_94_0# VSUBS
X0 a_94_0# a_30_260# a_n84_0# VSUBS nfet_03v3 ad=0.61p pd=3.22u as=0.61p ps=3.22u w=1u l=0.28u
.ends

.subckt sw_n nfet__0_0/VSUBS m1_n250_61# m1_n50_750# m1_136_61#
Xnfet__0_0 m1_n50_750# m1_n250_61# m1_136_61# nfet__0_0/VSUBS nfet__0
.ends

.subckt vh_seg a_5000_0# a_n128_0# VSUBS
X0 a_n128_0# a_5000_0# VSUBS ppolyf_u_1k r_width=1u r_length=25u
.ends

.subckt vhalf_res m1_n1050_650# m1_n650_50# m1_n650_10850# VSUBS
Xvh_seg_19 m1_5042_50# m1_n650_50# VSUBS vh_seg
Xvh_seg_0 m1_5042_10250# m1_n650_10850# VSUBS vh_seg
Xvh_seg_2 m1_5042_10250# m1_n342_9050# VSUBS vh_seg
Xvh_seg_1 m1_5042_9650# m1_n650_10850# VSUBS vh_seg
Xvh_seg_10 m1_5042_5450# m1_n342_4250# VSUBS vh_seg
Xvh_seg_3 m1_5042_9650# m1_n142_8450# VSUBS vh_seg
Xvh_seg_12 m1_5042_3050# m1_n342_4250# VSUBS vh_seg
Xvh_seg_11 m1_5042_4850# m1_n142_3650# VSUBS vh_seg
Xvh_seg_4 m1_5042_7850# m1_n342_9050# VSUBS vh_seg
Xvh_seg_13 m1_5042_2450# m1_n142_3650# VSUBS vh_seg
Xvh_seg_5 m1_5042_7250# m1_n142_8450# VSUBS vh_seg
Xvh_seg_14 m1_5042_3050# m1_n342_1850# VSUBS vh_seg
Xvh_seg_6 m1_5042_7850# m1_n342_6650# VSUBS vh_seg
Xvh_seg_15 m1_5042_2450# m1_n142_1250# VSUBS vh_seg
Xvh_seg_7 m1_5042_7250# m1_n142_6050# VSUBS vh_seg
Xvh_seg_16 m1_5042_650# m1_n342_1850# VSUBS vh_seg
Xvh_seg_8 m1_5042_5450# m1_n342_6650# VSUBS vh_seg
Xvh_seg_17 m1_5042_50# m1_n142_1250# VSUBS vh_seg
Xvh_seg_9 m1_5042_4850# m1_n142_6050# VSUBS vh_seg
Xvh_seg_18 m1_5042_650# m1_n1050_650# VSUBS vh_seg
.ends

.subckt row_b2 m1_1550_950# m1_5550_950# m1_9550_950# m1_1350_60# m1_6150_60# m1_2950_60#
+ m1_7750_60# m1_4140_60# m1_n250_60# m1_5740_60# m1_140_60# m1_3150_950# m1_7150_950#
+ m1_750_950# m1_5350_60# m1_6950_60# m1_3340_60# m1_4750_950# m1_8140_60# m1_4940_60#
+ m1_8750_950# m1_940_60# m1_9740_60# m1_n50_950# m1_4550_60# m1_2350_950# m1_9350_60#
+ m1_2540_60# m1_550_60# m1_6350_950# m1_7340_60# m1_8940_60# m1_7950_950# m1_3950_950#
+ m1_2150_60# w_n1060_n860# m1_3750_60# m1_8550_60# m1_1740_60# m1_6540_60#
Xpfet__1_0 m1_9550_950# w_n1060_n860# m1_9350_60# m1_9740_60# pfet__1
Xpfet__1_1 m1_8750_950# w_n1060_n860# m1_8550_60# m1_8940_60# pfet__1
Xpfet__1_2 m1_7950_950# w_n1060_n860# m1_7750_60# m1_8140_60# pfet__1
Xpfet__1_3 m1_7150_950# w_n1060_n860# m1_6950_60# m1_7340_60# pfet__1
Xpfet__1_5 m1_5550_950# w_n1060_n860# m1_5350_60# m1_5740_60# pfet__1
Xpfet__1_4 m1_6350_950# w_n1060_n860# m1_6150_60# m1_6540_60# pfet__1
Xpfet__1_6 m1_4750_950# w_n1060_n860# m1_4550_60# m1_4940_60# pfet__1
Xpfet__1_7 m1_3950_950# w_n1060_n860# m1_3750_60# m1_4140_60# pfet__1
Xpfet__1_8 m1_3150_950# w_n1060_n860# m1_2950_60# m1_3340_60# pfet__1
Xpfet__1_9 m1_2350_950# w_n1060_n860# m1_2150_60# m1_2540_60# pfet__1
Xpfet__1_10 m1_1550_950# w_n1060_n860# m1_1350_60# m1_1740_60# pfet__1
Xpfet__1_11 m1_750_950# w_n1060_n860# m1_550_60# m1_940_60# pfet__1
Xpfet__1_12 m1_n50_950# w_n1060_n860# m1_n250_60# m1_140_60# pfet__1
.ends

.subckt cap_mim__12 m4_n120_n120# m4_0_0#
X0 m4_0_0# m4_n120_n120# cap_mim_2f0_m4m5_noshield c_width=22.18u c_length=22.18u
.ends

.subckt vh_cap m4_4536_100# m4_5080_680#
Xcap_mim__12_0 m4_4536_100# m4_5080_680# cap_mim__12
.ends

.subckt row_a m1_8136_61# m1_4936_61# m1_16750_750# m1_750_750# m1_20136_61# m1_936_61#
+ m1_9736_61# nfet__0_9/VSUBS m1_13350_61# m1_4750_750# m1_18150_61# m1_14950_61#
+ m1_8750_750# m1_19750_61# m1_14536_61# m1_10350_750# m1_n50_750# m1_2536_61# m1_18350_750#
+ m1_14350_750# m1_19336_61# m1_7336_61# m1_8936_61# m1_6350_750# m1_2350_750# m1_11950_750#
+ m1_12136_61# m1_5350_61# m1_19950_750# m1_15950_750# m1_13736_61# m1_6950_61# m1_1736_61#
+ m1_3950_750# m1_18536_61# m1_6536_61# m1_7950_750# m1_10150_61# m1_11750_61# m1_13550_750#
+ m1_16550_61# m1_17550_750# m1_11336_61# m1_550_61# m1_16136_61# m1_12936_61# m1_1550_750#
+ m1_17736_61# m1_4136_61# m1_9550_750# m1_5550_750# m1_5736_61# m1_136_61# m1_15150_750#
+ m1_11150_750# m1_2150_61# m1_19150_750# m1_10536_61# m1_3750_61# m1_3150_750# m1_15336_61#
+ m1_8550_61# m1_7150_750# m1_16936_61# m1_3336_61# m1_12750_750#
Xnfet__0_22 m1_2350_750# m1_2150_61# m1_2536_61# nfet__0_9/VSUBS nfet__0
Xnfet__0_11 m1_11150_750# nfet__0_9/VSUBS m1_11336_61# nfet__0_9/VSUBS nfet__0
Xnfet__0_23 m1_1550_750# nfet__0_9/VSUBS m1_1736_61# nfet__0_9/VSUBS nfet__0
Xnfet__0_12 m1_10350_750# m1_10150_61# m1_10536_61# nfet__0_9/VSUBS nfet__0
Xnfet__0_24 m1_750_750# m1_550_61# m1_936_61# nfet__0_9/VSUBS nfet__0
Xnfet__0_13 m1_9550_750# nfet__0_9/VSUBS m1_9736_61# nfet__0_9/VSUBS nfet__0
Xnfet__0_25 m1_n50_750# nfet__0_9/VSUBS m1_136_61# nfet__0_9/VSUBS nfet__0
Xnfet__0_14 m1_8750_750# m1_8550_61# m1_8936_61# nfet__0_9/VSUBS nfet__0
Xnfet__0_15 m1_7950_750# nfet__0_9/VSUBS m1_8136_61# nfet__0_9/VSUBS nfet__0
Xnfet__0_17 m1_6350_750# nfet__0_9/VSUBS m1_6536_61# nfet__0_9/VSUBS nfet__0
Xnfet__0_16 m1_7150_750# m1_6950_61# m1_7336_61# nfet__0_9/VSUBS nfet__0
Xnfet__0_18 m1_5550_750# m1_5350_61# m1_5736_61# nfet__0_9/VSUBS nfet__0
Xnfet__0_19 m1_4750_750# nfet__0_9/VSUBS m1_4936_61# nfet__0_9/VSUBS nfet__0
Xnfet__0_0 m1_19950_750# m1_19750_61# m1_20136_61# nfet__0_9/VSUBS nfet__0
Xnfet__0_1 m1_19150_750# nfet__0_9/VSUBS m1_19336_61# nfet__0_9/VSUBS nfet__0
Xnfet__0_3 m1_17550_750# nfet__0_9/VSUBS m1_17736_61# nfet__0_9/VSUBS nfet__0
Xnfet__0_2 m1_18350_750# m1_18150_61# m1_18536_61# nfet__0_9/VSUBS nfet__0
Xnfet__0_4 m1_16750_750# m1_16550_61# m1_16936_61# nfet__0_9/VSUBS nfet__0
Xnfet__0_5 m1_15950_750# nfet__0_9/VSUBS m1_16136_61# nfet__0_9/VSUBS nfet__0
Xnfet__0_6 m1_15150_750# m1_14950_61# m1_15336_61# nfet__0_9/VSUBS nfet__0
Xnfet__0_7 m1_14350_750# nfet__0_9/VSUBS m1_14536_61# nfet__0_9/VSUBS nfet__0
Xnfet__0_8 m1_13550_750# m1_13350_61# m1_13736_61# nfet__0_9/VSUBS nfet__0
Xnfet__0_9 m1_12750_750# nfet__0_9/VSUBS m1_12936_61# nfet__0_9/VSUBS nfet__0
Xnfet__0_20 m1_3950_750# m1_3750_61# m1_4136_61# nfet__0_9/VSUBS nfet__0
Xnfet__0_21 m1_3150_750# nfet__0_9/VSUBS m1_3336_61# nfet__0_9/VSUBS nfet__0
Xnfet__0_10 m1_11950_750# m1_11750_61# m1_12136_61# nfet__0_9/VSUBS nfet__0
.ends

.subckt pfet__10 a_n92_0# a_62_n60# w_n214_n122# a_162_0#
X0 a_162_0# a_62_n60# a_n92_0# w_n214_n122# pfet_05v0 ad=0.9394p pd=3.98u as=0.9394p ps=3.98u w=1.22u l=0.5u
.ends

.subckt iv_p m1_74_377# w_n1260_n1060# m1_232_33#
Xpfet__10_0 w_n1260_n1060# m1_74_377# w_n1260_n1060# m1_232_33# pfet__10
.ends

.subckt nfet__13 a_n84_0# a_94_0# a_30_160# VSUBS
X0 a_94_0# a_30_160# a_n84_0# VSUBS nfet_03v3 ad=0.305p pd=2.22u as=0.305p ps=2.22u w=0.5u l=0.28u
.ends

.subckt xr0 m1_136_11# nfet__13_0/VSUBS m1_n250_11# m1_n50_550#
Xnfet__13_0 m1_n250_11# m1_136_11# m1_n50_550# nfet__13_0/VSUBS nfet__13
.ends

.subckt nfet__9 a_182_0# a_n84_0# a_62_n60# VSUBS
X0 a_182_0# a_62_n60# a_n84_0# VSUBS nfet_05v0 ad=0.5986p pd=3.1u as=0.5986p ps=3.1u w=0.82u l=0.6u
.ends

.subckt iv_n nfet__9_0/VSUBS m1_248_43# m1_84_295#
Xnfet__9_0 m1_248_43# nfet__9_0/VSUBS m1_84_295# nfet__9_0/VSUBS nfet__9
.ends

.subckt row_b1 m1_1550_950# m1_5550_950# m1_9550_950# m1_4140_60# m1_5740_60# m1_140_60#
+ m1_3150_950# m1_7150_950# m1_750_950# m1_3340_60# m1_4750_950# m1_8140_60# m1_4940_60#
+ m1_8750_950# m1_940_60# m1_9740_60# m1_2350_950# m1_2540_60# m1_6350_950# m1_7340_60#
+ m1_8940_60# m1_7950_950# m1_3950_950# w_n1060_n860# m1_1740_60# m1_6540_60#
Xpfet__1_0 m1_9550_950# w_n1060_n860# w_n1060_n860# m1_9740_60# pfet__1
Xpfet__1_1 m1_8750_950# w_n1060_n860# w_n1060_n860# m1_8940_60# pfet__1
Xpfet__1_2 m1_7950_950# w_n1060_n860# w_n1060_n860# m1_8140_60# pfet__1
Xpfet__1_3 m1_7150_950# w_n1060_n860# w_n1060_n860# m1_7340_60# pfet__1
Xpfet__1_5 m1_5550_950# w_n1060_n860# w_n1060_n860# m1_5740_60# pfet__1
Xpfet__1_4 m1_6350_950# w_n1060_n860# w_n1060_n860# m1_6540_60# pfet__1
Xpfet__1_6 m1_4750_950# w_n1060_n860# w_n1060_n860# m1_4940_60# pfet__1
Xpfet__1_7 m1_3950_950# w_n1060_n860# w_n1060_n860# m1_4140_60# pfet__1
Xpfet__1_8 m1_3150_950# w_n1060_n860# w_n1060_n860# m1_3340_60# pfet__1
Xpfet__1_9 m1_2350_950# w_n1060_n860# w_n1060_n860# m1_2540_60# pfet__1
Xpfet__1_10 m1_1550_950# w_n1060_n860# w_n1060_n860# m1_1740_60# pfet__1
Xpfet__1_11 m1_750_950# w_n1060_n860# w_n1060_n860# m1_940_60# pfet__1
Xpfet__1_12 w_n1060_n860# w_n1060_n860# w_n1060_n860# m1_140_60# pfet__1
.ends

.subckt cxa_x m4_1100_100# m4_1480_680#
Xcap_mim__2_0 m4_1100_100# m4_1480_680# cap_mim__2
.ends

.subckt nfet__6 a_38_n60# a_n84_0# a_138_0# VSUBS
X0 a_138_0# a_38_n60# a_n84_0# VSUBS nfet_03v3 ad=4.88p pd=17.22u as=4.88p ps=17.22u w=8u l=0.5u
.ends

.subckt nfet__7 a_30_860# a_n84_0# a_94_0# VSUBS
X0 a_94_0# a_30_860# a_n84_0# VSUBS nfet_03v3 ad=2.44p pd=9.22u as=2.44p ps=9.22u w=4u l=0.28u
.ends

.subckt nfet__5 a_n84_0# a_94_0# a_30_460# VSUBS
X0 a_94_0# a_30_460# a_n84_0# VSUBS nfet_03v3 ad=1.22p pd=5.22u as=1.22p ps=5.22u w=2u l=0.28u
.ends

.subckt cn_x m1_1736_56# nfet__7_0/VSUBS m1_2536_61# m1_3150_950# m1_2350_750# m1_n50_950#
+ m1_1350_56# m1_1550_1350# m1_136_60# m1_750_2150# m1_980_48# m1_3336_60#
Xnfet__6_0 m1_750_2150# nfet__7_0/VSUBS m1_980_48# nfet__7_0/VSUBS nfet__6
Xnfet__0_0 m1_2350_750# nfet__7_0/VSUBS m1_2536_61# nfet__7_0/VSUBS nfet__0
Xnfet__7_0 m1_1550_1350# m1_1350_56# m1_1736_56# nfet__7_0/VSUBS nfet__7
Xnfet__5_0 nfet__7_0/VSUBS m1_3336_60# m1_3150_950# nfet__7_0/VSUBS nfet__5
Xnfet__5_1 nfet__7_0/VSUBS m1_136_60# m1_n50_950# nfet__7_0/VSUBS nfet__5
.ends

.subckt pfet__8 w_n180_n88# a_n92_0# a_94_0# a_28_860#
X0 a_94_0# a_28_860# a_n92_0# w_n180_n88# pfet_03v3 ad=2.6p pd=9.3u as=2.6p ps=9.3u w=4u l=0.28u
.ends

.subckt cp_x m1_1550_950# m1_2540_56# m1_750_950# m1_940_60# m1_2350_1350# m1_140_56#
+ m1_n50_1350# w_n1060_n860# m1_1740_60#
Xpfet__1_0 m1_1550_950# w_n1060_n860# w_n1060_n860# m1_1740_60# pfet__1
Xpfet__1_1 m1_750_950# w_n1060_n860# w_n1060_n860# m1_940_60# pfet__1
Xpfet__8_0 w_n1060_n860# w_n1060_n860# m1_2540_56# m1_2350_1350# pfet__8
Xpfet__8_1 w_n1060_n860# w_n1060_n860# m1_140_56# m1_n50_1350# pfet__8
.ends

.subckt pfet__4 a_750_0# a_546_0# a_446_n60# a_242_n60# w_n180_n88# a_38_n60# a_n92_0#
+ a_342_0# a_138_0# a_650_n60#
X0 a_342_0# a_242_n60# a_138_0# w_n180_n88# pfet_03v3 ad=5.2p pd=20.52u as=5.2p ps=20.52u w=20u l=0.5u
X1 a_546_0# a_446_n60# a_342_0# w_n180_n88# pfet_03v3 ad=5.2p pd=20.52u as=5.2p ps=20.52u w=20u l=0.5u
X2 a_138_0# a_38_n60# a_n92_0# w_n180_n88# pfet_03v3 ad=5.2p pd=20.52u as=13p ps=41.3u w=20u l=0.5u
X3 a_750_0# a_650_n60# a_546_0# w_n180_n88# pfet_03v3 ad=13p pd=41.3u as=5.2p ps=20.52u w=20u l=0.5u
.ends

.subckt pair_x w_n1060_n1060# m1_n84_n498# m1_n500_3900# m1_140_3738#
Xpfet__4_0 m1_n84_n498# m1_140_3738# m1_n500_3900# m1_n500_3900# w_n1060_n1060# m1_n500_3900#
+ m1_n84_n498# m1_n84_n498# m1_140_3738# m1_n500_3900# pfet__4
.ends

.subckt cmp_side m1_3950_6550# m1_1950_6350# m1_1550_6550# m1_6750_5150# m1_550_4750#
+ m1_1150_6750# m1_7150_750# m1_950_1750# VSUBS
Xcxa_x_0 VSUBS m1_1350_1550# cxa_x
Xcn_x_0 m1_1550_6550# VSUBS m1_3150_6150# m1_3150_6150# m1_1550_6550# m1_950_1750#
+ m1_2150_2750# m1_1150_6750# m1_1350_1550# m1_1350_1550# m1_2150_2750# m1_3950_6550#
+ cn_x
Xcp_x_0 m1_1550_6550# m1_3950_6550# m1_1950_6350# m1_1550_6550# m1_3150_6150# m1_1550_6550#
+ m1_1150_6750# m1_550_4750# m1_3150_6150# cp_x
Xpair_x_0 m1_550_4750# m1_7150_750# m1_6750_5150# m1_1350_1550# pair_x
.ends

.subckt cc_p m1_750_950# m1_940_60# m1_140_56# m1_n50_1350# w_n1060_n860#
Xpfet__1_0 m1_750_950# w_n1060_n860# w_n1060_n860# m1_940_60# pfet__1
Xpfet__8_0 w_n1060_n860# w_n1060_n860# m1_140_56# m1_n50_1350# pfet__8
.ends

.subckt cc_n nfet__0_0/VSUBS m1_n50_750# m1_136_61#
Xnfet__0_0 m1_n50_750# nfet__0_0/VSUBS m1_136_61# nfet__0_0/VSUBS nfet__0
.ends

.subckt cmp_blk m1_n50_6750# m3_n11650_7150# m1_1350_1550# m3_11550_7150# m3_11550_550#
+ VSUBS
Xcmp_side_0 cmp_side_0/m1_3950_6550# m1_n50_6750# m3_n1850_2350# m3_n11650_7150# m1_1350_1550#
+ m2_n1850_2750# m1_150_3350# m1_n250_3550# VSUBS cmp_side
Xcc_p_0 m1_n50_6750# m1_n250_3550# m1_150_3350# m1_n250_3550# m1_1350_1550# cc_p
Xcmp_side_1 m3_11550_550# m1_n50_6750# m2_n1850_2750# m3_11550_7150# m1_1350_1550#
+ m3_n1850_2350# m1_150_3350# m1_n250_3550# VSUBS cmp_side
Xcc_n_0 VSUBS m1_n50_6750# m1_n250_3550# cc_n
.ends

.subckt xr1 m1_136_11# nfet__13_0/VSUBS m1_n250_11# m1_n50_550#
Xnfet__13_0 m1_n250_11# m1_136_11# m1_n50_550# nfet__13_0/VSUBS nfet__13
.ends

.subckt cap_mim__11 m4_n120_n120# m4_0_0#
X0 m4_0_0# m4_n120_n120# cap_mim_2f0_m4m5_noshield c_width=59.07u c_length=59.07u
.ends

.subckt cref m4_11914_100# m4_12280_680#
Xcap_mim__11_0 m4_11914_100# m4_12280_680# cap_mim__11
.ends

.subckt adc_ch rst_sw tg_on dac_gdn cmp_clk cmp_q dac_gp[11] dac_gn[11] dac_gp[10]
+ dac_gn[10] dac_gp[9] dac_gn[9] dac_gp[8] dac_gn[8] dac_gp[7] dac_gn[7] dac_gp[6]
+ dac_gn[6] dac_gp[5] dac_gn[5] dac_gp[4] dac_gn[4] dac_gp[3] dac_gn[3] dac_gp[2]
+ dac_gn[2] dac_gp[1] dac_gn[1] dac_gp[0] dac_gn[0] vin vdd_cmp vdd_dac vss vdd
Xsw_p_0 m1_2350_8350# m1_48950_11350# m1_16150_5750# vdd sw_p
Xdac_0 m1_5550_5550# m1_4750_5550# m1_13550_5550# m1_27950_8350# m1_13550_5550# m1_7950_5550#
+ m1_9550_5550# m1_6350_5550# m1_11150_5550# vss m1_11950_5550# m1_6350_5550# m1_7150_5550#
+ m1_12750_5550# m1_2950_8350# m1_7150_5550# m1_3750_2150# m1_5550_5550# m1_11150_5550#
+ m1_10350_5550# m1_8750_5550# m1_8750_5550# m1_11950_5550# m1_12750_5550# m1_7950_5550#
+ m1_10350_5550# vss dac
Xsw_n_0 vss m1_2350_8350# tg_on m1_48950_11350# sw_n
Xvhalf_res_0 vss vdd m1_2350_8350# vss vhalf_res
Xrow_b2_0 m1_16150_5750# m1_16150_5750# m1_16150_5750# vin vin vin vin m1_7950_5550#
+ vin m1_9550_5550# m1_3750_2150# m1_16150_5750# m1_16150_5750# m1_16150_5750# vin
+ vin m1_7150_5550# m1_16150_5750# m1_11950_5550# m1_8750_5550# m1_16150_5750# m1_4750_5550#
+ m1_13550_5550# m1_16150_5750# vin m1_16150_5750# vin m1_6350_5550# vin m1_16150_5750#
+ m1_11150_5550# m1_12750_5550# m1_16150_5750# m1_16150_5750# vin vdd vin vin m1_5550_5550#
+ m1_10350_5550# row_b2
Xvh_cap_0 vss m1_2350_8350# vh_cap
Xrow_a_0 m1_7950_5550# m1_6350_5550# tg_on tg_on m1_13550_5550# m1_3750_2150# m1_8750_5550#
+ vss vin dac_gn[2] vin vin tg_on vin m1_11150_5550# tg_on dac_gdn m1_4750_5550# tg_on
+ dac_gn[8] m1_13550_5550# m1_7150_5550# m1_7950_5550# dac_gn[3] tg_on tg_on m1_9550_5550#
+ vin tg_on dac_gn[9] m1_10350_5550# vin m1_4750_5550# tg_on m1_12750_5550# m1_7150_5550#
+ dac_gn[4] vin vin tg_on vin dac_gn[10] m1_9550_5550# vin m1_11950_5550# m1_10350_5550#
+ dac_gn[0] m1_12750_5550# m1_5550_5550# dac_gn[5] tg_on m1_6350_5550# m1_3750_2150#
+ tg_on dac_gn[6] vin dac_gn[11] m1_8750_5550# vin dac_gn[1] m1_11150_5550# vin tg_on
+ m1_11950_5550# m1_5550_5550# dac_gn[7] row_a
Xiv_p_0 tg_on vdd m1_16150_5750# iv_p
Xxr0_0 m1_27950_8350# vss m1_2350_8350# rst_sw xr0
Xiv_n_0 vss m1_16150_5750# tg_on iv_n
Xrow_b1_0 dac_gp[1] dac_gp[6] dac_gp[11] m1_7950_5550# m1_9550_5550# m1_3750_2150#
+ dac_gp[3] dac_gp[8] dac_gp[0] m1_7150_5550# dac_gp[5] m1_11950_5550# m1_8750_5550#
+ dac_gp[10] m1_4750_5550# m1_13550_5550# dac_gp[2] m1_6350_5550# dac_gp[7] m1_11150_5550#
+ m1_12750_5550# dac_gp[9] dac_gp[4] vdd_dac m1_5550_5550# m1_10350_5550# row_b1
Xcmp_blk_0 cmp_clk m1_27950_8350# vdd_cmp m1_48950_11350# cmp_q vss cmp_blk
Xxr1_0 m1_2950_8350# vss m1_2350_8350# rst_sw xr1
Xcref_0 vss m1_48950_11350# cref
.ends
