* NGSPICE file created from adc_ch (flattened) - technology: gf180mcuD
* MIM correction of flow.py pex: capacitance to the layers below that Magic attached to MIM TOP plates was moved to the bottom plates:
*   a_1094_7200#: 13.25 fF -> a_5894_3600# + a_5294_3600# + a_2094_1000# + a_4694_3600# + a_4094_3600# + a_3494_3600# + a_2894_3600#; a_21494_7200#: 13.54 fF -> a_9494_3600# + a_8294_3600# + a_6494_3600# + a_8894_3600# + a_7694_3600# + a_1094_7200# + a_7094_3600#; a_23316_2302#: 0.34 fF -> vss; a_26694_9400#: 26.73 fF -> vss; a_35494_1800#: 0.21 fF -> vss; a_916_7200#: 4.11 fF -> vss
.subckt adc_ch rst_sw tg_on dac_gdn cmp_clk cmp_q dac_gp[11] dac_gn[11] dac_gp[10]  dac_gn[10] dac_gp[9] dac_gn[9] dac_gp[8] dac_gn[8] dac_gp[7] dac_gn[7] dac_gp[6]  dac_gn[6] dac_gp[5] dac_gn[5] dac_gp[4] dac_gn[4] dac_gp[3] dac_gn[3] dac_gp[2]  dac_gn[2] dac_gp[1] dac_gn[1] dac_gp[0] dac_gn[0] vin vdd_cmp vdd_dac vss vdd
X0 a_11828_4060# tg_on vss vss nfet_05v0 ad=0.5986p pd=3.1u as=0.5986p ps=3.1u w=0.82u l=0.6u
X1 a_1094_7200# a_5894_3600# cap_mim_2f0_m4m5_noshield c_width=5u c_length=5u
X2 a_4094_3600# dac_gp[2] vdd_dac vdd_dac pfet_03v3 ad=1.3p pd=5.3u as=1.3p ps=5.3u w=2u l=0.28u
X3 vss a_23316_2302# a_28562_1800# vss nfet_03v3 ad=4.88p pd=17.22u as=4.88p ps=17.22u w=8u l=0.5u
X4 a_21494_7200# a_9494_3600# cap_mim_2f0_m4m5_noshield c_width=5u c_length=5u
X5 a_2894_3600# dac_gn[0] vss vss nfet_03v3 ad=0.61p pd=3.22u as=0.61p ps=3.22u w=1u l=0.28u
X6 a_28498_2660# a_27698_2060# a_36338_1800# vss nfet_03v3 ad=2.44p pd=9.22u as=2.44p ps=9.22u w=4u l=0.28u
X7 a_23546_2302# a_26694_9400# a_35494_1800# vdd_cmp pfet_03v3 ad=4.16p pd=16.52u as=4.16p ps=16.52u w=16u l=0.5u
X8 a_3494_3600# a_11828_4060# vin vdd pfet_03v3 ad=1.3p pd=5.3u as=1.3p ps=5.3u w=2u l=0.28u
X9 a_28498_2660# cmp_clk vdd_cmp vdd_cmp pfet_03v3 ad=1.3p pd=5.3u as=1.3p ps=5.3u w=2u l=0.28u
X10 a_21494_7200# a_9494_3600# cap_mim_2f0_m4m5_noshield c_width=5u c_length=5u
X11 a_21494_7200# a_9494_3600# cap_mim_2f0_m4m5_noshield c_width=5u c_length=5u
X12 a_21494_7200# a_8294_3600# cap_mim_2f0_m4m5_noshield c_width=5u c_length=5u
X13 a_1094_7200# a_5294_3600# cap_mim_2f0_m4m5_noshield c_width=5u c_length=5u
X14 a_1094_7200# a_2094_1000# cap_mim_2f0_m4m5_noshield c_width=5u c_length=5u
X15 a_1094_7200# a_5294_3600# cap_mim_2f0_m4m5_noshield c_width=5u c_length=5u
X16 a_1094_7200# a_5894_3600# cap_mim_2f0_m4m5_noshield c_width=5u c_length=5u
X17 a_7094_3600# a_11828_4060# vin vdd pfet_03v3 ad=1.3p pd=5.3u as=1.3p ps=5.3u w=2u l=0.28u
X18 a_1094_7200# a_5894_3600# cap_mim_2f0_m4m5_noshield c_width=5u c_length=5u
X19 a_1094_7200# a_5894_3600# cap_mim_2f0_m4m5_noshield c_width=5u c_length=5u
X20 a_37294_5800# a_28498_2660# vss vss nfet_03v3 ad=0.61p pd=3.22u as=0.61p ps=3.22u w=1u l=0.28u
X21 a_1094_7200# a_4694_3600# cap_mim_2f0_m4m5_noshield c_width=5u c_length=5u
X22 a_21494_7200# a_9494_3600# cap_mim_2f0_m4m5_noshield c_width=5u c_length=5u
X23 a_21494_7200# a_8294_3600# cap_mim_2f0_m4m5_noshield c_width=5u c_length=5u
X24 a_2094_1000# dac_gdn vss vss nfet_03v3 ad=0.61p pd=3.22u as=0.61p ps=3.22u w=1u l=0.28u
X25 a_35494_1800# a_26694_9400# a_23546_2302# vdd_cmp pfet_03v3 ad=10.4p pd=33.3u as=4.16p ps=16.52u w=16u l=0.5u
X26 a_23546_2302# a_21494_7200# a_23316_2302# vdd_cmp pfet_03v3 ad=4.16p pd=16.52u as=4.16p ps=16.52u w=16u l=0.5u
X27 a_21494_7200# a_9494_3600# cap_mim_2f0_m4m5_noshield c_width=5u c_length=5u
X28 a_21494_7200# a_6494_3600# cap_mim_2f0_m4m5_noshield c_width=5u c_length=5u
X29 vdd_cmp a_26898_2260# a_26784_1800# vdd_cmp pfet_03v3 ad=2.6p pd=9.3u as=2.6p ps=9.3u w=4u l=0.28u
X30 a_3494_3600# dac_gp[1] vdd_dac vdd_dac pfet_03v3 ad=1.3p pd=5.3u as=1.3p ps=5.3u w=2u l=0.28u
X31 a_21494_7200# a_9494_3600# cap_mim_2f0_m4m5_noshield c_width=5u c_length=5u
X32 a_1094_7200# a_4094_3600# cap_mim_2f0_m4m5_noshield c_width=5u c_length=5u
X33 a_6494_3600# dac_gn[6] vss vss nfet_03v3 ad=0.61p pd=3.22u as=0.61p ps=3.22u w=1u l=0.28u
X34 a_26694_9400# vss cap_mim_2f0_m4m5_noshield c_width=59.07u c_length=59.07u
X35 a_2094_1000# tg_on vin vss nfet_03v3 ad=0.61p pd=3.22u as=0.61p ps=3.22u w=1u l=0.28u
X36 a_28562_1800# a_28498_2660# a_27698_2060# vss nfet_03v3 ad=2.44p pd=9.22u as=2.44p ps=9.22u w=4u l=0.28u
X37 a_21494_7200# a_9494_3600# cap_mim_2f0_m4m5_noshield c_width=5u c_length=5u
X38 a_1094_7200# a_4694_3600# cap_mim_2f0_m4m5_noshield c_width=5u c_length=5u
X39 a_8294_3600# dac_gp[9] vdd_dac vdd_dac pfet_03v3 ad=1.3p pd=5.3u as=1.3p ps=5.3u w=2u l=0.28u
X40 a_1094_7200# a_4694_3600# cap_mim_2f0_m4m5_noshield c_width=5u c_length=5u
X41 a_5872_7120# a_18500_8000# vss ppolyf_u_1k r_width=1u r_length=62.5u
X42 a_4694_3600# dac_gn[3] vss vss nfet_03v3 ad=0.61p pd=3.22u as=0.61p ps=3.22u w=1u l=0.28u
X43 a_9494_3600# a_11828_4060# vin vdd pfet_03v3 ad=1.3p pd=5.3u as=1.3p ps=5.3u w=2u l=0.28u
X44 a_5894_3600# dac_gn[5] vss vss nfet_03v3 ad=0.61p pd=3.22u as=0.61p ps=3.22u w=1u l=0.28u
X45 a_1094_7200# a_5894_3600# cap_mim_2f0_m4m5_noshield c_width=5u c_length=5u
X46 a_21494_7200# a_9494_3600# cap_mim_2f0_m4m5_noshield c_width=5u c_length=5u
X47 a_1094_7200# a_5894_3600# cap_mim_2f0_m4m5_noshield c_width=5u c_length=5u
X48 a_1094_7200# a_5294_3600# cap_mim_2f0_m4m5_noshield c_width=5u c_length=5u
X49 a_1094_7200# a_5294_3600# cap_mim_2f0_m4m5_noshield c_width=5u c_length=5u
X50 a_21494_7200# a_8894_3600# cap_mim_2f0_m4m5_noshield c_width=5u c_length=5u
X51 a_21494_7200# a_8294_3600# cap_mim_2f0_m4m5_noshield c_width=5u c_length=5u
X52 a_26694_9400# a_11828_4060# a_916_7200# vdd pfet_03v3 ad=1.3p pd=5.3u as=1.3p ps=5.3u w=2u l=0.28u
X53 a_30098_2260# cmp_clk vdd_cmp vdd_cmp pfet_03v3 ad=1.3p pd=5.3u as=1.3p ps=5.3u w=2u l=0.28u
X54 a_21494_7200# a_8894_3600# cap_mim_2f0_m4m5_noshield c_width=5u c_length=5u
X55 a_35494_1800# a_30098_2260# vss vss nfet_03v3 ad=1.22p pd=5.22u as=1.22p ps=5.22u w=2u l=0.28u
X56 a_1094_7200# a_4694_3600# cap_mim_2f0_m4m5_noshield c_width=5u c_length=5u
X57 a_2094_1000# a_11828_4060# vin vdd pfet_03v3 ad=1.3p pd=5.3u as=1.3p ps=5.3u w=2u l=0.28u
X58 a_4094_3600# dac_gn[2] vss vss nfet_03v3 ad=0.61p pd=3.22u as=0.61p ps=3.22u w=1u l=0.28u
X59 a_21494_7200# a_8294_3600# cap_mim_2f0_m4m5_noshield c_width=5u c_length=5u
X60 a_916_7200# a_18500_8000# vss ppolyf_u_1k r_width=1u r_length=62.5u
X61 a_2894_3600# dac_gp[0] vdd_dac vdd_dac pfet_03v3 ad=1.3p pd=5.3u as=1.3p ps=5.3u w=2u l=0.28u
X62 a_21494_7200# rst_sw a_916_7200# vss nfet_03v3 ad=0.305p pd=2.22u as=0.305p ps=2.22u w=0.5u l=0.28u
X63 a_21494_7200# a_7694_3600# cap_mim_2f0_m4m5_noshield c_width=5u c_length=5u
X64 a_23546_2302# a_26694_9400# a_35494_1800# vdd_cmp pfet_03v3 ad=4.16p pd=16.52u as=4.16p ps=16.52u w=16u l=0.5u
X65 a_21494_7200# a_9494_3600# cap_mim_2f0_m4m5_noshield c_width=5u c_length=5u
X66 a_11828_4060# tg_on vdd vdd pfet_05v0 ad=0.9394p pd=3.98u as=0.9394p ps=3.98u w=1.22u l=0.5u
X67 a_5894_3600# a_11828_4060# vin vdd pfet_03v3 ad=1.3p pd=5.3u as=1.3p ps=5.3u w=2u l=0.28u
X68 a_35494_1800# a_26694_9400# a_23546_2302# vdd_cmp pfet_03v3 ad=4.16p pd=16.52u as=10.4p ps=33.3u w=16u l=0.5u
X69 a_1094_7200# a_5294_3600# cap_mim_2f0_m4m5_noshield c_width=5u c_length=5u
X70 a_1094_7200# a_5294_3600# cap_mim_2f0_m4m5_noshield c_width=5u c_length=5u
X71 a_7694_3600# dac_gp[8] vdd_dac vdd_dac pfet_03v3 ad=1.3p pd=5.3u as=1.3p ps=5.3u w=2u l=0.28u
X72 a_5872_7120# a_18500_6240# vss ppolyf_u_1k r_width=1u r_length=62.5u
X73 a_1094_7200# a_5294_3600# cap_mim_2f0_m4m5_noshield c_width=5u c_length=5u
X74 a_1094_7200# a_4094_3600# cap_mim_2f0_m4m5_noshield c_width=5u c_length=5u
X75 a_1094_7200# a_5294_3600# cap_mim_2f0_m4m5_noshield c_width=5u c_length=5u
X76 a_1094_7200# a_5894_3600# cap_mim_2f0_m4m5_noshield c_width=5u c_length=5u
X77 a_21494_7200# a_1094_7200# cap_mim_2f0_m4m5_noshield c_width=5.085u c_length=5u
X78 a_1094_7200# a_4694_3600# cap_mim_2f0_m4m5_noshield c_width=5u c_length=5u
X79 a_1094_7200# a_4694_3600# cap_mim_2f0_m4m5_noshield c_width=5u c_length=5u
X80 a_1094_7200# a_3494_3600# cap_mim_2f0_m4m5_noshield c_width=5u c_length=5u
X81 a_1094_7200# rst_sw a_916_7200# vss nfet_03v3 ad=0.305p pd=2.22u as=0.305p ps=2.22u w=0.5u l=0.28u
X82 a_7694_3600# dac_gn[8] vss vss nfet_03v3 ad=0.61p pd=3.22u as=0.61p ps=3.22u w=1u l=0.28u
X83 a_3494_3600# tg_on vin vss nfet_03v3 ad=0.61p pd=3.22u as=0.61p ps=3.22u w=1u l=0.28u
X84 vss a_26898_2260# a_26784_1800# vss nfet_03v3 ad=1.22p pd=5.22u as=1.22p ps=5.22u w=2u l=0.28u
X85 a_1094_7200# a_5894_3600# cap_mim_2f0_m4m5_noshield c_width=5u c_length=5u
X86 a_1094_7200# a_5294_3600# cap_mim_2f0_m4m5_noshield c_width=5u c_length=5u
X87 a_21494_7200# a_9494_3600# cap_mim_2f0_m4m5_noshield c_width=5u c_length=5u
X88 a_1094_7200# a_5294_3600# cap_mim_2f0_m4m5_noshield c_width=5u c_length=5u
X89 a_1094_7200# a_5894_3600# cap_mim_2f0_m4m5_noshield c_width=5u c_length=5u
X90 a_21494_7200# a_8294_3600# cap_mim_2f0_m4m5_noshield c_width=5u c_length=5u
X91 vss a_18500_6240# vss ppolyf_u_1k r_width=1u r_length=62.5u
X92 a_21494_7200# a_8294_3600# cap_mim_2f0_m4m5_noshield c_width=5u c_length=5u
X93 a_23316_2302# vss cap_mim_2f0_m4m5_noshield c_width=5u c_length=5u
X94 a_21494_7200# a_8894_3600# cap_mim_2f0_m4m5_noshield c_width=5u c_length=5u
X95 a_21494_7200# a_8894_3600# cap_mim_2f0_m4m5_noshield c_width=5u c_length=5u
X96 a_7094_3600# dac_gn[7] vss vss nfet_03v3 ad=0.61p pd=3.22u as=0.61p ps=3.22u w=1u l=0.28u
X97 a_2894_3600# tg_on vin vss nfet_03v3 ad=0.61p pd=3.22u as=0.61p ps=3.22u w=1u l=0.28u
X98 a_37294_5800# a_28498_2660# vdd_cmp vdd_cmp pfet_03v3 ad=1.3p pd=5.3u as=1.3p ps=5.3u w=2u l=0.28u
X99 a_21494_7200# a_7694_3600# cap_mim_2f0_m4m5_noshield c_width=5u c_length=5u
X100 a_4094_3600# a_11828_4060# vin vdd pfet_03v3 ad=1.3p pd=5.3u as=1.3p ps=5.3u w=2u l=0.28u
X101 a_1094_7200# a_5894_3600# cap_mim_2f0_m4m5_noshield c_width=5u c_length=5u
X102 a_21494_7200# a_9494_3600# cap_mim_2f0_m4m5_noshield c_width=5u c_length=5u
X103 a_1094_7200# a_5894_3600# cap_mim_2f0_m4m5_noshield c_width=5u c_length=5u
X104 a_5294_3600# dac_gp[4] vdd_dac vdd_dac pfet_03v3 ad=1.3p pd=5.3u as=1.3p ps=5.3u w=2u l=0.28u
X105 a_1094_7200# a_5894_3600# cap_mim_2f0_m4m5_noshield c_width=5u c_length=5u
X106 a_1094_7200# a_5294_3600# cap_mim_2f0_m4m5_noshield c_width=5u c_length=5u
X107 a_5294_3600# dac_gn[4] vss vss nfet_03v3 ad=0.61p pd=3.22u as=0.61p ps=3.22u w=1u l=0.28u
X108 a_21494_7200# a_9494_3600# cap_mim_2f0_m4m5_noshield c_width=5u c_length=5u
X109 a_1094_7200# a_5294_3600# cap_mim_2f0_m4m5_noshield c_width=5u c_length=5u
X110 a_7694_3600# a_11828_4060# vin vdd pfet_03v3 ad=1.3p pd=5.3u as=1.3p ps=5.3u w=2u l=0.28u
X111 a_1094_7200# a_5894_3600# cap_mim_2f0_m4m5_noshield c_width=5u c_length=5u
X112 cmp_q a_37294_5800# vss vss nfet_03v3 ad=1.22p pd=5.22u as=1.22p ps=5.22u w=2u l=0.28u
X113 a_21494_7200# a_9494_3600# cap_mim_2f0_m4m5_noshield c_width=5u c_length=5u
X114 a_1094_7200# a_4694_3600# cap_mim_2f0_m4m5_noshield c_width=5u c_length=5u
X115 a_9494_3600# dac_gn[11] vss vss nfet_03v3 ad=0.61p pd=3.22u as=0.61p ps=3.22u w=1u l=0.28u
X116 a_5294_3600# tg_on vin vss nfet_03v3 ad=0.61p pd=3.22u as=0.61p ps=3.22u w=1u l=0.28u
X117 a_8294_3600# a_11828_4060# vin vdd pfet_03v3 ad=1.3p pd=5.3u as=1.3p ps=5.3u w=2u l=0.28u
X118 a_35494_1800# a_26694_9400# a_23546_2302# vdd_cmp pfet_03v3 ad=4.16p pd=16.52u as=4.16p ps=16.52u w=16u l=0.5u
X119 vdd_cmp a_27698_2060# a_26898_2260# vdd_cmp pfet_03v3 ad=1.3p pd=5.3u as=1.3p ps=5.3u w=2u l=0.28u
X120 a_1094_7200# a_5894_3600# cap_mim_2f0_m4m5_noshield c_width=5u c_length=5u
X121 a_21494_7200# a_9494_3600# cap_mim_2f0_m4m5_noshield c_width=5u c_length=5u
X122 a_1094_7200# a_5294_3600# cap_mim_2f0_m4m5_noshield c_width=5u c_length=5u
X123 a_6494_3600# tg_on vin vss nfet_03v3 ad=0.61p pd=3.22u as=0.61p ps=3.22u w=1u l=0.28u
X124 a_1094_7200# a_5894_3600# cap_mim_2f0_m4m5_noshield c_width=5u c_length=5u
X125 a_1094_7200# a_5294_3600# cap_mim_2f0_m4m5_noshield c_width=5u c_length=5u
X126 a_21494_7200# a_8294_3600# cap_mim_2f0_m4m5_noshield c_width=5u c_length=5u
X127 a_4694_3600# dac_gp[3] vdd_dac vdd_dac pfet_03v3 ad=1.3p pd=5.3u as=1.3p ps=5.3u w=2u l=0.28u
X128 a_1094_7200# a_5894_3600# cap_mim_2f0_m4m5_noshield c_width=5u c_length=5u
X129 a_8894_3600# dac_gn[10] vss vss nfet_03v3 ad=0.61p pd=3.22u as=0.61p ps=3.22u w=1u l=0.28u
X130 a_21494_7200# a_9494_3600# cap_mim_2f0_m4m5_noshield c_width=5u c_length=5u
X131 a_21494_7200# a_8894_3600# cap_mim_2f0_m4m5_noshield c_width=5u c_length=5u
X132 a_21494_7200# a_8294_3600# cap_mim_2f0_m4m5_noshield c_width=5u c_length=5u
X133 a_4694_3600# tg_on vin vss nfet_03v3 ad=0.61p pd=3.22u as=0.61p ps=3.22u w=1u l=0.28u
X134 a_21494_7200# a_8894_3600# cap_mim_2f0_m4m5_noshield c_width=5u c_length=5u
X135 a_9494_3600# dac_gp[11] vdd_dac vdd_dac pfet_03v3 ad=1.3p pd=5.3u as=1.3p ps=5.3u w=2u l=0.28u
X136 a_1094_7200# a_5894_3600# cap_mim_2f0_m4m5_noshield c_width=5u c_length=5u
X137 a_5894_3600# tg_on vin vss nfet_03v3 ad=0.61p pd=3.22u as=0.61p ps=3.22u w=1u l=0.28u
X138 a_1094_7200# a_5894_3600# cap_mim_2f0_m4m5_noshield c_width=5u c_length=5u
X139 a_1094_7200# a_5894_3600# cap_mim_2f0_m4m5_noshield c_width=5u c_length=5u
X140 a_21494_7200# a_9494_3600# cap_mim_2f0_m4m5_noshield c_width=5u c_length=5u
X141 a_21494_7200# a_7694_3600# cap_mim_2f0_m4m5_noshield c_width=5u c_length=5u
X142 a_1094_7200# a_2894_3600# cap_mim_2f0_m4m5_noshield c_width=5u c_length=5u
X143 a_23316_2302# a_21494_7200# a_23546_2302# vdd_cmp pfet_03v3 ad=4.16p pd=16.52u as=4.16p ps=16.52u w=16u l=0.5u
X144 a_1094_7200# a_4094_3600# cap_mim_2f0_m4m5_noshield c_width=5u c_length=5u
X145 a_26694_9400# tg_on a_916_7200# vss nfet_03v3 ad=0.61p pd=3.22u as=0.61p ps=3.22u w=1u l=0.28u
X146 a_8294_3600# dac_gn[9] vss vss nfet_03v3 ad=0.61p pd=3.22u as=0.61p ps=3.22u w=1u l=0.28u
X147 a_36338_1800# a_35494_1800# vss vss nfet_03v3 ad=4.88p pd=17.22u as=4.88p ps=17.22u w=8u l=0.5u
X148 a_4094_3600# tg_on vin vss nfet_03v3 ad=0.61p pd=3.22u as=0.61p ps=3.22u w=1u l=0.28u
X149 a_28498_2660# a_27698_2060# vdd_cmp vdd_cmp pfet_03v3 ad=2.6p pd=9.3u as=2.6p ps=9.3u w=4u l=0.28u
X150 a_1094_7200# a_5894_3600# cap_mim_2f0_m4m5_noshield c_width=5u c_length=5u
X151 a_21494_7200# a_8894_3600# cap_mim_2f0_m4m5_noshield c_width=5u c_length=5u
X152 a_2894_3600# a_11828_4060# vin vdd pfet_03v3 ad=1.3p pd=5.3u as=1.3p ps=5.3u w=2u l=0.28u
X153 a_21494_7200# a_8894_3600# cap_mim_2f0_m4m5_noshield c_width=5u c_length=5u
X154 a_21494_7200# a_9494_3600# cap_mim_2f0_m4m5_noshield c_width=5u c_length=5u
X155 a_1094_7200# a_5894_3600# cap_mim_2f0_m4m5_noshield c_width=5u c_length=5u
X156 a_21494_7200# a_8894_3600# cap_mim_2f0_m4m5_noshield c_width=5u c_length=5u
X157 a_21494_7200# a_8894_3600# cap_mim_2f0_m4m5_noshield c_width=5u c_length=5u
X158 a_6494_3600# a_11828_4060# vin vdd pfet_03v3 ad=1.3p pd=5.3u as=1.3p ps=5.3u w=2u l=0.28u
X159 a_21494_7200# a_9494_3600# cap_mim_2f0_m4m5_noshield c_width=5u c_length=5u
X160 a_1094_7200# a_5894_3600# cap_mim_2f0_m4m5_noshield c_width=5u c_length=5u
X161 a_1094_7200# a_5894_3600# cap_mim_2f0_m4m5_noshield c_width=5u c_length=5u
X162 a_8294_3600# tg_on vin vss nfet_03v3 ad=0.61p pd=3.22u as=0.61p ps=3.22u w=1u l=0.28u
X163 a_23546_2302# a_21494_7200# a_23316_2302# vdd_cmp pfet_03v3 ad=10.4p pd=33.3u as=4.16p ps=16.52u w=16u l=0.5u
X164 a_1094_7200# a_5294_3600# cap_mim_2f0_m4m5_noshield c_width=5u c_length=5u
X165 a_1094_7200# a_5294_3600# cap_mim_2f0_m4m5_noshield c_width=5u c_length=5u
X166 a_8894_3600# dac_gp[10] vdd_dac vdd_dac pfet_03v3 ad=1.3p pd=5.3u as=1.3p ps=5.3u w=2u l=0.28u
X167 a_916_7200# a_18500_7560# vss ppolyf_u_1k r_width=1u r_length=62.5u
X168 a_2094_1000# vdd_dac vdd_dac vdd_dac pfet_03v3 ad=1.3p pd=5.3u as=1.3p ps=5.3u w=2u l=0.28u
X169 a_1094_7200# a_5894_3600# cap_mim_2f0_m4m5_noshield c_width=5u c_length=5u
X170 a_21494_7200# a_9494_3600# cap_mim_2f0_m4m5_noshield c_width=5u c_length=5u
X171 a_21494_7200# a_8894_3600# cap_mim_2f0_m4m5_noshield c_width=5u c_length=5u
X172 a_21494_7200# a_9494_3600# cap_mim_2f0_m4m5_noshield c_width=5u c_length=5u
X173 a_21494_7200# a_8894_3600# cap_mim_2f0_m4m5_noshield c_width=5u c_length=5u
X174 a_7094_3600# dac_gp[7] vdd_dac vdd_dac pfet_03v3 ad=1.3p pd=5.3u as=1.3p ps=5.3u w=2u l=0.28u
X175 a_21494_7200# a_9494_3600# cap_mim_2f0_m4m5_noshield c_width=5u c_length=5u
X176 a_7694_3600# tg_on vin vss nfet_03v3 ad=0.61p pd=3.22u as=0.61p ps=3.22u w=1u l=0.28u
X177 a_1094_7200# a_5894_3600# cap_mim_2f0_m4m5_noshield c_width=5u c_length=5u
X178 vss a_27698_2060# a_26898_2260# vss nfet_03v3 ad=0.61p pd=3.22u as=0.61p ps=3.22u w=1u l=0.28u
X179 a_21494_7200# a_7694_3600# cap_mim_2f0_m4m5_noshield c_width=5u c_length=5u
X180 a_1094_7200# a_4094_3600# cap_mim_2f0_m4m5_noshield c_width=5u c_length=5u
X181 a_1094_7200# a_5894_3600# cap_mim_2f0_m4m5_noshield c_width=5u c_length=5u
X182 a_21494_7200# a_9494_3600# cap_mim_2f0_m4m5_noshield c_width=5u c_length=5u
X183 a_21494_7200# a_9494_3600# cap_mim_2f0_m4m5_noshield c_width=5u c_length=5u
X184 a_1094_7200# a_5894_3600# cap_mim_2f0_m4m5_noshield c_width=5u c_length=5u
X185 a_8894_3600# a_11828_4060# vin vdd pfet_03v3 ad=1.3p pd=5.3u as=1.3p ps=5.3u w=2u l=0.28u
X186 a_21494_7200# a_7094_3600# cap_mim_2f0_m4m5_noshield c_width=5u c_length=5u
X187 vdd a_18500_5800# vss ppolyf_u_1k r_width=1u r_length=62.5u
X188 a_7094_3600# tg_on vin vss nfet_03v3 ad=0.61p pd=3.22u as=0.61p ps=3.22u w=1u l=0.28u
X189 a_5872_6680# a_18500_7560# vss ppolyf_u_1k r_width=1u r_length=62.5u
X190 a_4694_3600# a_11828_4060# vin vdd pfet_03v3 ad=1.3p pd=5.3u as=1.3p ps=5.3u w=2u l=0.28u
X191 cmp_q a_37294_5800# vdd_cmp vdd_cmp pfet_03v3 ad=2.6p pd=9.3u as=2.6p ps=9.3u w=4u l=0.28u
X192 a_21494_7200# a_9494_3600# cap_mim_2f0_m4m5_noshield c_width=5u c_length=5u
X193 a_21494_7200# a_8894_3600# cap_mim_2f0_m4m5_noshield c_width=5u c_length=5u
X194 a_21494_7200# a_8894_3600# cap_mim_2f0_m4m5_noshield c_width=5u c_length=5u
X195 vss a_30098_2260# a_23316_2302# vss nfet_03v3 ad=1.22p pd=5.22u as=1.22p ps=5.22u w=2u l=0.28u
X196 a_23546_2302# a_30098_2260# vdd_cmp vdd_cmp pfet_03v3 ad=2.6p pd=9.3u as=2.6p ps=9.3u w=4u l=0.28u
X197 a_21494_7200# a_9494_3600# cap_mim_2f0_m4m5_noshield c_width=5u c_length=5u
X198 a_1094_7200# a_5894_3600# cap_mim_2f0_m4m5_noshield c_width=5u c_length=5u
X199 a_21494_7200# a_7094_3600# cap_mim_2f0_m4m5_noshield c_width=5u c_length=5u
X200 a_1094_7200# a_5894_3600# cap_mim_2f0_m4m5_noshield c_width=5u c_length=5u
X201 a_1094_7200# a_5894_3600# cap_mim_2f0_m4m5_noshield c_width=5u c_length=5u
X202 a_6494_3600# dac_gp[6] vdd_dac vdd_dac pfet_03v3 ad=1.3p pd=5.3u as=1.3p ps=5.3u w=2u l=0.28u
X203 a_1094_7200# a_3494_3600# cap_mim_2f0_m4m5_noshield c_width=5u c_length=5u
X204 a_23546_2302# a_21494_7200# a_23316_2302# vdd_cmp pfet_03v3 ad=4.16p pd=16.52u as=10.4p ps=33.3u w=16u l=0.5u
X205 a_35494_1800# vss cap_mim_2f0_m4m5_noshield c_width=5u c_length=5u
X206 a_916_7200# vss cap_mim_2f0_m4m5_noshield c_width=22.18u c_length=22.18u
X207 a_5294_3600# a_11828_4060# vin vdd pfet_03v3 ad=1.3p pd=5.3u as=1.3p ps=5.3u w=2u l=0.28u
X208 a_21494_7200# a_9494_3600# cap_mim_2f0_m4m5_noshield c_width=5u c_length=5u
X209 a_21494_7200# a_8894_3600# cap_mim_2f0_m4m5_noshield c_width=5u c_length=5u
X210 a_21494_7200# a_8894_3600# cap_mim_2f0_m4m5_noshield c_width=5u c_length=5u
X211 a_9494_3600# tg_on vin vss nfet_03v3 ad=0.61p pd=3.22u as=0.61p ps=3.22u w=1u l=0.28u
X212 a_21494_7200# a_9494_3600# cap_mim_2f0_m4m5_noshield c_width=5u c_length=5u
X213 a_1094_7200# a_5894_3600# cap_mim_2f0_m4m5_noshield c_width=5u c_length=5u
X214 vdd_cmp cmp_clk a_27698_2060# vdd_cmp pfet_03v3 ad=1.3p pd=5.3u as=1.3p ps=5.3u w=2u l=0.28u
X215 a_21494_7200# a_9494_3600# cap_mim_2f0_m4m5_noshield c_width=5u c_length=5u
X216 a_21494_7200# a_9494_3600# cap_mim_2f0_m4m5_noshield c_width=5u c_length=5u
X217 a_5872_6680# a_18500_5800# vss ppolyf_u_1k r_width=1u r_length=62.5u
X218 a_23316_2302# a_21494_7200# a_23546_2302# vdd_cmp pfet_03v3 ad=4.16p pd=16.52u as=4.16p ps=16.52u w=16u l=0.5u
X219 a_1094_7200# a_5894_3600# cap_mim_2f0_m4m5_noshield c_width=5u c_length=5u
X220 a_21494_7200# a_9494_3600# cap_mim_2f0_m4m5_noshield c_width=5u c_length=5u
X221 a_3494_3600# dac_gn[1] vss vss nfet_03v3 ad=0.61p pd=3.22u as=0.61p ps=3.22u w=1u l=0.28u
X222 a_8894_3600# tg_on vin vss nfet_03v3 ad=0.61p pd=3.22u as=0.61p ps=3.22u w=1u l=0.28u
X223 vdd_cmp a_28498_2660# a_27698_2060# vdd_cmp pfet_03v3 ad=2.6p pd=9.3u as=2.6p ps=9.3u w=4u l=0.28u
X224 a_5894_3600# dac_gp[5] vdd_dac vdd_dac pfet_03v3 ad=1.3p pd=5.3u as=1.3p ps=5.3u w=2u l=0.28u
X225 a_30098_2260# cmp_clk vss vss nfet_03v3 ad=0.61p pd=3.22u as=0.61p ps=3.22u w=1u l=0.28u
X226 a_21494_7200# a_9494_3600# cap_mim_2f0_m4m5_noshield c_width=5u c_length=5u
X227 a_21494_7200# a_9494_3600# cap_mim_2f0_m4m5_noshield c_width=5u c_length=5u
X228 a_1094_7200# a_4694_3600# cap_mim_2f0_m4m5_noshield c_width=5u c_length=5u
C0 a_1094_7200# a_18500_7560# 0.00022479f
C1 a_1094_7200# a_18500_8000# 0.0014044f
C2 a_1094_7200# a_2094_1000# 0.96769f
C3 a_1094_7200# a_21494_7200# 1.6816f
C4 a_1094_7200# a_2894_3600# 1.3629f
C5 a_1094_7200# a_3494_3600# 1.3927f
C6 a_1094_7200# a_4094_3600# 2.1966f
C7 a_1094_7200# a_4694_3600# 4.3021f
C8 a_1094_7200# a_5294_3600# 8.6021f
C9 a_1094_7200# a_5894_3600# 16.461f
C10 a_1094_7200# a_6494_3600# 0.00073951f
C11 a_1094_7200# a_7094_3600# 0.29211f
C12 a_1094_7200# a_7694_3600# 0.00052393f
C13 a_1094_7200# a_8294_3600# 0.18705f
C14 a_1094_7200# a_8894_3600# 0.1857f
C15 a_1094_7200# a_916_7200# 0.11647f
C16 a_1094_7200# a_9494_3600# 0.012268f
C17 a_1094_7200# rst_sw 0.24264f
C18 a_1094_7200# vin 0.05987f
C19 a_1094_7200# vss 10.552f
C20 a_11828_4060# a_2094_1000# 0.13784f
C21 a_11828_4060# a_21494_7200# 0.06723f
C22 a_11828_4060# a_23316_2302# 0.43663f
C23 a_11828_4060# a_23546_2302# 0.14983f
C24 a_11828_4060# a_26694_9400# 0.21626f
C25 a_11828_4060# a_26784_1800# 0.07202f
C26 a_11828_4060# a_26898_2260# 0.08511f
C27 a_11828_4060# a_27698_2060# 0.99985f
C28 a_11828_4060# a_28498_2660# 0.2661f
C29 a_11828_4060# a_2894_3600# 0.16555f
C30 a_11828_4060# a_3494_3600# 0.86962f
C31 a_11828_4060# a_4094_3600# 0.13645f
C32 a_11828_4060# a_4694_3600# 0.35117f
C33 a_11828_4060# a_5294_3600# 0.14562f
C34 a_11828_4060# a_5894_3600# 0.18541f
C35 a_11828_4060# a_6494_3600# 0.68407f
C36 a_11828_4060# a_7094_3600# 0.38427f
C37 a_11828_4060# a_7694_3600# 0.2264f
C38 a_11828_4060# a_8294_3600# 0.24944f
C39 a_11828_4060# a_8894_3600# 0.22866f
C40 a_11828_4060# a_916_7200# 0.39519f
C41 a_11828_4060# a_9494_3600# 1.5044f
C42 a_11828_4060# cmp_clk 0.0339f
C43 a_11828_4060# rst_sw 0.0974f
C44 a_11828_4060# tg_on 1.1917f
C45 a_11828_4060# vdd 10.736f
C46 a_11828_4060# vdd_cmp 0.73702f
C47 a_11828_4060# vin 3.5303f
C48 a_11828_4060# vss 2.8127f
C49 a_18500_5800# a_18500_6240# 0.29096f
C50 a_18500_5800# a_916_7200# 0.0274f
C51 a_18500_5800# vss 0.73078f
C52 a_18500_6240# a_18500_7560# 0.02293f
C53 a_18500_6240# a_18500_8000# 0.01615f
C54 a_18500_6240# a_916_7200# 0.04388f
C55 a_18500_6240# vss 0.87016f
C56 a_18500_7560# a_18500_8000# 0.29096f
C57 a_18500_7560# a_6494_3600# 0.00022104f
C58 a_18500_7560# a_7094_3600# 0.00044207f
C59 a_18500_7560# a_7694_3600# 0.00088414f
C60 a_18500_7560# a_8294_3600# 0.0017683f
C61 a_18500_7560# a_8894_3600# 0.0035366f
C62 a_18500_7560# a_9494_3600# 0.022203f
C63 a_18500_7560# vss 0.72948f
C64 a_18500_8000# a_6494_3600# 0.0013809f
C65 a_18500_8000# a_7094_3600# 0.0027618f
C66 a_18500_8000# a_7694_3600# 0.0055235f
C67 a_18500_8000# a_8294_3600# 0.011047f
C68 a_18500_8000# a_8894_3600# 0.022094f
C69 a_18500_8000# a_9494_3600# 0.10051f
C70 a_18500_8000# vss 0.91636f
C71 a_2094_1000# a_2894_3600# 2.572f
C72 a_2094_1000# a_3494_3600# 0.7095f
C73 a_2094_1000# a_4094_3600# 4.2719f
C74 a_2094_1000# a_4694_3600# 0.99484f
C75 a_2094_1000# a_5294_3600# 4.1515f
C76 a_2094_1000# a_5894_3600# 0.8303f
C77 a_2094_1000# a_6494_3600# 2.0408f
C78 a_2094_1000# a_7094_3600# 0.06654f
C79 a_2094_1000# a_7694_3600# 0.07038f
C80 a_2094_1000# a_8294_3600# 0.04998f
C81 a_2094_1000# a_8894_3600# 0.05344f
C82 a_2094_1000# a_916_7200# 0.07219f
C83 a_2094_1000# a_9494_3600# 0.06403f
C84 a_2094_1000# dac_gdn 0.37894f
C85 a_2094_1000# dac_gn[0] 0.11062f
C86 a_2094_1000# dac_gp[0] 0.4946f
C87 a_2094_1000# dac_gp[10] 0.0501f
C88 a_2094_1000# dac_gp[11] 0.06008f
C89 a_2094_1000# dac_gp[1] 0.14241f
C90 a_2094_1000# dac_gp[2] 0.073f
C91 a_2094_1000# dac_gp[3] 0.06948f
C92 a_2094_1000# dac_gp[4] 0.05735f
C93 a_2094_1000# dac_gp[5] 0.06948f
C94 a_2094_1000# dac_gp[6] 0.0617f
C95 a_2094_1000# dac_gp[7] 0.06986f
C96 a_2094_1000# dac_gp[8] 0.06602f
C97 a_2094_1000# dac_gp[9] 0.05545f
C98 a_2094_1000# rst_sw 0.26231f
C99 a_2094_1000# tg_on 0.25898f
C100 a_2094_1000# vdd 0.45121f
C101 a_2094_1000# vdd_dac 1.4682f
C102 a_2094_1000# vin 1.3026f
C103 a_2094_1000# vss 3.569f
C104 a_21494_7200# a_23316_2302# 2.3344f
C105 a_21494_7200# a_23546_2302# 1.3362f
C106 a_21494_7200# a_26784_1800# 0.12355f
C107 a_21494_7200# a_2894_3600# 0.02143f
C108 a_21494_7200# a_4694_3600# 0.37227f
C109 a_21494_7200# a_5894_3600# 0.01226f
C110 a_21494_7200# a_6494_3600# 1.2424f
C111 a_21494_7200# a_7094_3600# 1.3474f
C112 a_21494_7200# a_7694_3600# 2.2458f
C113 a_21494_7200# a_8294_3600# 4.2166f
C114 a_21494_7200# a_8894_3600# 8.7616f
C115 a_21494_7200# a_916_7200# 0.1962f
C116 a_21494_7200# a_9494_3600# 18.291f
C117 a_21494_7200# cmp_clk 0.01869f
C118 a_21494_7200# cmp_q 0.01606f
C119 a_21494_7200# rst_sw 0.08171f
C120 a_21494_7200# tg_on 0.01761f
C121 a_21494_7200# vdd 0.20903f
C122 a_21494_7200# vdd_cmp 2.0297f
C123 a_21494_7200# vdd_dac 0.03361f
C124 a_21494_7200# vss 10.234f
C125 a_23316_2302# a_23546_2302# 5.5881f
C126 a_23316_2302# a_26784_1800# 0.31723f
C127 a_23316_2302# a_26898_2260# 0.11343f
C128 a_23316_2302# a_27698_2060# 0.5534f
C129 a_23316_2302# a_28498_2660# 0.3666f
C130 a_23316_2302# a_28562_1800# 0.35878f
C131 a_23316_2302# a_30098_2260# 0.08757f
C132 a_23316_2302# a_4694_3600# 0.57231f
C133 a_23316_2302# a_6494_3600# 0.27606f
C134 a_23316_2302# a_7094_3600# 0.12624f
C135 a_23316_2302# a_7694_3600# 0.15715f
C136 a_23316_2302# a_8294_3600# 0.20741f
C137 a_23316_2302# a_8894_3600# 0.05603f
C138 a_23316_2302# a_916_7200# 0.08878f
C139 a_23316_2302# a_9494_3600# 0.75015f
C140 a_23316_2302# cmp_clk 0.11531f
C141 a_23316_2302# cmp_q 0.13076f
C142 a_23316_2302# tg_on 0.08365f
C143 a_23316_2302# vdd 0.33543f
C144 a_23316_2302# vdd_cmp 1.5616f
C145 a_23316_2302# vdd_dac 0.07189f
C146 a_23316_2302# vss 5.1056f
C147 a_23546_2302# a_26694_9400# 1.3362f
C148 a_23546_2302# a_26784_1800# 0.57068f
C149 a_23546_2302# a_26898_2260# 0.25404f
C150 a_23546_2302# a_27698_2060# 0.35306f
C151 a_23546_2302# a_28498_2660# 0.37175f
C152 a_23546_2302# a_28562_1800# 0.2614f
C153 a_23546_2302# a_30098_2260# 0.79523f
C154 a_23546_2302# a_35494_1800# 5.6213f
C155 a_23546_2302# a_36338_1800# 0.2614f
C156 a_23546_2302# a_37294_5800# 0.25404f
C157 a_23546_2302# a_4694_3600# 0.21136f
C158 a_23546_2302# a_6494_3600# 0.01089f
C159 a_23546_2302# a_7094_3600# 0.03647f
C160 a_23546_2302# a_7694_3600# 0.04769f
C161 a_23546_2302# a_8294_3600# 0.03891f
C162 a_23546_2302# a_9494_3600# 0.14773f
C163 a_23546_2302# cmp_clk 1.5397f
C164 a_23546_2302# cmp_q 0.95977f
C165 a_23546_2302# tg_on 0.94816f
C166 a_23546_2302# vdd 0.40807f
C167 a_23546_2302# vdd_cmp 4.3197f
C168 a_23546_2302# vdd_dac 0.16485f
C169 a_23546_2302# vss 5.2781f
C170 a_26694_9400# a_35494_1800# 2.4156f
C171 a_26694_9400# a_916_7200# 0.5741f
C172 a_26694_9400# cmp_q 0.18281f
C173 a_26694_9400# tg_on 0.11888f
C174 a_26694_9400# vdd 1.1373f
C175 a_26694_9400# vdd_cmp 2.1421f
C176 a_26694_9400# vss 14.134f
C177 a_26784_1800# a_26898_2260# 0.57081f
C178 a_26784_1800# a_4694_3600# 0.11841f
C179 a_26784_1800# a_7694_3600# 0.01136f
C180 a_26784_1800# a_9494_3600# 0.10728f
C181 a_26784_1800# cmp_clk 0.11715f
C182 a_26784_1800# cmp_q 0.345f
C183 a_26784_1800# tg_on 1.9301f
C184 a_26784_1800# vdd 0.07764f
C185 a_26784_1800# vdd_cmp 1.9827f
C186 a_26784_1800# vdd_dac 0.11493f
C187 a_26784_1800# vss 1.662f
C188 a_26898_2260# a_27698_2060# 0.60485f
C189 a_26898_2260# a_28498_2660# 0.13464f
C190 a_26898_2260# cmp_clk 0.0915f
C191 a_26898_2260# cmp_q 0.12676f
C192 a_26898_2260# tg_on 0.04924f
C193 a_26898_2260# vdd 0.49874f
C194 a_26898_2260# vdd_cmp 1.508f
C195 a_26898_2260# vdd_dac 0.33554f
C196 a_26898_2260# vss 1.6535f
C197 a_27698_2060# a_28498_2660# 3.3474f
C198 a_27698_2060# a_28562_1800# 0.76547f
C199 a_27698_2060# a_30098_2260# 0.63038f
C200 a_27698_2060# a_35494_1800# 0.3666f
C201 a_27698_2060# a_36338_1800# 0.2323f
C202 a_27698_2060# a_37294_5800# 0.13888f
C203 a_27698_2060# cmp_clk 1.3823f
C204 a_27698_2060# cmp_q 0.09701f
C205 a_27698_2060# vdd 0.76623f
C206 a_27698_2060# vdd_cmp 3.51f
C207 a_27698_2060# vdd_dac 0.24762f
C208 a_27698_2060# vss 5.0278f
C209 a_28498_2660# a_28562_1800# 0.2323f
C210 a_28498_2660# a_30098_2260# 0.71773f
C211 a_28498_2660# a_35494_1800# 0.55406f
C212 a_28498_2660# a_36338_1800# 0.76547f
C213 a_28498_2660# a_37294_5800# 0.8418f
C214 a_28498_2660# cmp_clk 1.3629f
C215 a_28498_2660# cmp_q 0.27966f
C216 a_28498_2660# vdd 0.28909f
C217 a_28498_2660# vdd_cmp 3.6174f
C218 a_28498_2660# vdd_dac 0.01026f
C219 a_28498_2660# vss 4.7108f
C220 a_28562_1800# cmp_clk 0.02586f
C221 a_28562_1800# cmp_q 0.05994f
C222 a_28562_1800# vdd_cmp 0.01936f
C223 a_28562_1800# vdd_dac 0.04099f
C224 a_28562_1800# vss 1.5664f
C225 a_2894_3600# a_3494_3600# 3.4283f
C226 a_2894_3600# a_4094_3600# 2.0826f
C227 a_2894_3600# a_4694_3600# 4.9418f
C228 a_2894_3600# a_5294_3600# 2.5048f
C229 a_2894_3600# a_5894_3600# 0.95142f
C230 a_2894_3600# a_6494_3600# 0.32506f
C231 a_2894_3600# a_7094_3600# 0.16733f
C232 a_2894_3600# a_7694_3600# 0.20657f
C233 a_2894_3600# a_8294_3600# 0.1343f
C234 a_2894_3600# a_8894_3600# 0.13667f
C235 a_2894_3600# a_916_7200# 0.06133f
C236 a_2894_3600# a_9494_3600# 0.14452f
C237 a_2894_3600# cmp_clk 0.16108f
C238 a_2894_3600# cmp_q 0.02595f
C239 a_2894_3600# dac_gn[0] 0.23529f
C240 a_2894_3600# dac_gn[1] 0.1035f
C241 a_2894_3600# dac_gp[0] 0.42766f
C242 a_2894_3600# dac_gp[10] 0.13818f
C243 a_2894_3600# dac_gp[11] 0.14646f
C244 a_2894_3600# dac_gp[1] 0.7923f
C245 a_2894_3600# dac_gp[2] 0.57613f
C246 a_2894_3600# dac_gp[3] 0.14674f
C247 a_2894_3600# dac_gp[4] 0.13829f
C248 a_2894_3600# dac_gp[5] 0.1513f
C249 a_2894_3600# dac_gp[6] 0.1124f
C250 a_2894_3600# dac_gp[7] 0.16572f
C251 a_2894_3600# dac_gp[8] 0.15684f
C252 a_2894_3600# dac_gp[9] 0.13953f
C253 a_2894_3600# rst_sw 1.2601f
C254 a_2894_3600# tg_on 0.32507f
C255 a_2894_3600# vdd 0.70049f
C256 a_2894_3600# vdd_dac 1.758f
C257 a_2894_3600# vin 2.1724f
C258 a_2894_3600# vss 5.2776f
C259 a_30098_2260# a_35494_1800# 0.08757f
C260 a_30098_2260# cmp_clk 2.4139f
C261 a_30098_2260# cmp_q 0.10836f
C262 a_30098_2260# vdd 0.06626f
C263 a_30098_2260# vdd_cmp 2.8074f
C264 a_30098_2260# vss 3.5154f
C265 a_3494_3600# a_4094_3600# 5.1923f
C266 a_3494_3600# a_4694_3600# 2.5836f
C267 a_3494_3600# a_5294_3600# 1.0382f
C268 a_3494_3600# a_5894_3600# 0.59284f
C269 a_3494_3600# a_6494_3600# 0.28192f
C270 a_3494_3600# a_7094_3600# 0.0304f
C271 a_3494_3600# a_7694_3600# 0.01922f
C272 a_3494_3600# a_8894_3600# 0.01699f
C273 a_3494_3600# a_916_7200# 0.0581f
C274 a_3494_3600# a_9494_3600# 0.01691f
C275 a_3494_3600# cmp_clk 0.06528f
C276 a_3494_3600# cmp_q 0.32599f
C277 a_3494_3600# dac_gn[0] 0.0142f
C278 a_3494_3600# dac_gn[11] 0.02887f
C279 a_3494_3600# dac_gn[1] 0.22645f
C280 a_3494_3600# dac_gn[2] 0.10799f
C281 a_3494_3600# dac_gp[0] 0.24303f
C282 a_3494_3600# dac_gp[10] 0.10411f
C283 a_3494_3600# dac_gp[11] 0.28246f
C284 a_3494_3600# dac_gp[1] 0.30011f
C285 a_3494_3600# dac_gp[2] 0.32421f
C286 a_3494_3600# dac_gp[3] 0.42582f
C287 a_3494_3600# dac_gp[4] 1.0692f
C288 a_3494_3600# dac_gp[5] 0.10549f
C289 a_3494_3600# dac_gp[6] 0.0478f
C290 a_3494_3600# dac_gp[7] 0.18077f
C291 a_3494_3600# dac_gp[8] 0.19122f
C292 a_3494_3600# dac_gp[9] 0.18077f
C293 a_3494_3600# rst_sw 1.1725f
C294 a_3494_3600# tg_on 0.31027f
C295 a_3494_3600# vdd 3.7239f
C296 a_3494_3600# vdd_dac 2.8179f
C297 a_3494_3600# vin 1.5273f
C298 a_3494_3600# vss 5.6256f
C299 a_35494_1800# a_36338_1800# 0.35878f
C300 a_35494_1800# a_37294_5800# 0.12657f
C301 a_35494_1800# cmp_q 0.56185f
C302 a_35494_1800# vdd 0.67188f
C303 a_35494_1800# vdd_cmp 1.729f
C304 a_35494_1800# vss 5.4337f
C305 a_36338_1800# a_37294_5800# 0.01866f
C306 a_36338_1800# cmp_q 0.0776f
C307 a_36338_1800# vss 1.5762f
C308 a_37294_5800# cmp_q 0.72669f
C309 a_37294_5800# vdd 0.08014f
C310 a_37294_5800# vdd_cmp 1.578f
C311 a_37294_5800# vss 1.7769f
C312 a_4094_3600# a_4694_3600# 1.7368f
C313 a_4094_3600# a_5294_3600# 5.8157f
C314 a_4094_3600# a_5894_3600# 0.44053f
C315 a_4094_3600# a_6494_3600# 0.98061f
C316 a_4094_3600# a_7094_3600# 0.20226f
C317 a_4094_3600# a_7694_3600# 0.06443f
C318 a_4094_3600# a_8294_3600# 0.05067f
C319 a_4094_3600# a_8894_3600# 0.0516f
C320 a_4094_3600# a_916_7200# 0.06404f
C321 a_4094_3600# a_9494_3600# 0.05657f
C322 a_4094_3600# cmp_clk 0.07698f
C323 a_4094_3600# cmp_q 0.05642f
C324 a_4094_3600# dac_gn[0] 0.01391f
C325 a_4094_3600# dac_gn[10] 0.03395f
C326 a_4094_3600# dac_gn[11] 0.0323f
C327 a_4094_3600# dac_gn[2] 0.22468f
C328 a_4094_3600# dac_gn[3] 0.1035f
C329 a_4094_3600# dac_gp[0] 0.13577f
C330 a_4094_3600# dac_gp[10] 0.06965f
C331 a_4094_3600# dac_gp[11] 0.16169f
C332 a_4094_3600# dac_gp[1] 0.18915f
C333 a_4094_3600# dac_gp[2] 0.35078f
C334 a_4094_3600# dac_gp[3] 0.2911f
C335 a_4094_3600# dac_gp[4] 0.11409f
C336 a_4094_3600# dac_gp[5] 0.11198f
C337 a_4094_3600# dac_gp[6] 0.77832f
C338 a_4094_3600# dac_gp[7] 0.24962f
C339 a_4094_3600# dac_gp[8] 0.05021f
C340 a_4094_3600# dac_gp[9] 0.04733f
C341 a_4094_3600# rst_sw 0.37955f
C342 a_4094_3600# tg_on 0.32494f
C343 a_4094_3600# vdd 0.4261f
C344 a_4094_3600# vdd_dac 0.88886f
C345 a_4094_3600# vin 5.3129f
C346 a_4094_3600# vss 4.8375f
C347 a_4694_3600# a_5294_3600# 3.0804f
C348 a_4694_3600# a_5894_3600# 7.3896f
C349 a_4694_3600# a_6494_3600# 0.40943f
C350 a_4694_3600# a_7094_3600# 5.7545f
C351 a_4694_3600# a_7694_3600# 2.7513f
C352 a_4694_3600# a_8294_3600# 3.0026f
C353 a_4694_3600# a_8894_3600# 0.69215f
C354 a_4694_3600# a_916_7200# 0.09579f
C355 a_4694_3600# a_9494_3600# 3.1958f
C356 a_4694_3600# cmp_clk 0.08845f
C357 a_4694_3600# cmp_q 0.0681f
C358 a_4694_3600# dac_gn[10] 0.0179f
C359 a_4694_3600# dac_gn[11] 0.02378f
C360 a_4694_3600# dac_gn[3] 0.22232f
C361 a_4694_3600# dac_gn[4] 0.10272f
C362 a_4694_3600# dac_gn[9] 0.11005f
C363 a_4694_3600# dac_gp[0] 0.13817f
C364 a_4694_3600# dac_gp[10] 0.07204f
C365 a_4694_3600# dac_gp[11] 0.12752f
C366 a_4694_3600# dac_gp[1] 0.18315f
C367 a_4694_3600# dac_gp[2] 0.1425f
C368 a_4694_3600# dac_gp[3] 0.42838f
C369 a_4694_3600# dac_gp[4] 0.22203f
C370 a_4694_3600# dac_gp[5] 0.12956f
C371 a_4694_3600# dac_gp[6] 0.11874f
C372 a_4694_3600# dac_gp[7] 0.46209f
C373 a_4694_3600# dac_gp[8] 0.55086f
C374 a_4694_3600# dac_gp[9] 0.16262f
C375 a_4694_3600# rst_sw 0.50542f
C376 a_4694_3600# tg_on 0.3015f
C377 a_4694_3600# vdd 1.4006f
C378 a_4694_3600# vdd_cmp 0.80705f
C379 a_4694_3600# vdd_dac 1.5468f
C380 a_4694_3600# vin 7.1918f
C381 a_4694_3600# vss 12.149f
C382 a_5294_3600# a_5894_3600# 6.7365f
C383 a_5294_3600# a_6494_3600# 0.4293f
C384 a_5294_3600# a_7094_3600# 2.7828f
C385 a_5294_3600# a_7694_3600# 0.50752f
C386 a_5294_3600# a_8294_3600# 0.15117f
C387 a_5294_3600# a_8894_3600# 0.50856f
C388 a_5294_3600# a_916_7200# 0.0648f
C389 a_5294_3600# a_9494_3600# 0.06742f
C390 a_5294_3600# cmp_clk 0.25599f
C391 a_5294_3600# cmp_q 0.05216f
C392 a_5294_3600# dac_gn[10] 0.01609f
C393 a_5294_3600# dac_gn[11] 0.02626f
C394 a_5294_3600# dac_gn[4] 0.2476f
C395 a_5294_3600# dac_gn[5] 0.13792f
C396 a_5294_3600# dac_gn[8] 0.02035f
C397 a_5294_3600# dac_gn[9] 0.17213f
C398 a_5294_3600# dac_gp[0] 0.15112f
C399 a_5294_3600# dac_gp[10] 0.31363f
C400 a_5294_3600# dac_gp[11] 0.64797f
C401 a_5294_3600# dac_gp[1] 0.2056f
C402 a_5294_3600# dac_gp[2] 0.14526f
C403 a_5294_3600# dac_gp[3] 0.1387f
C404 a_5294_3600# dac_gp[4] 0.42001f
C405 a_5294_3600# dac_gp[5] 0.3353f
C406 a_5294_3600# dac_gp[6] 0.12398f
C407 a_5294_3600# dac_gp[7] 0.0549f
C408 a_5294_3600# dac_gp[8] 0.04688f
C409 a_5294_3600# dac_gp[9] 0.04622f
C410 a_5294_3600# rst_sw 0.11548f
C411 a_5294_3600# tg_on 0.32138f
C412 a_5294_3600# vdd 0.44952f
C413 a_5294_3600# vdd_dac 1.0289f
C414 a_5294_3600# vin 1.7405f
C415 a_5294_3600# vss 9.0364f
C416 a_5872_6680# a_5872_7120# 0.29096f
C417 a_5872_6680# a_916_7200# 0.02592f
C418 a_5872_6680# vss 0.74999f
C419 a_5872_7120# a_916_7200# 0.12221f
C420 a_5872_7120# vss 0.88327f
C421 a_5894_3600# a_6494_3600# 0.29258f
C422 a_5894_3600# a_7094_3600# 0.57697f
C423 a_5894_3600# a_7694_3600# 0.66369f
C424 a_5894_3600# a_8294_3600# 2.7872f
C425 a_5894_3600# a_8894_3600# 0.26064f
C426 a_5894_3600# a_916_7200# 0.21099f
C427 a_5894_3600# a_9494_3600# 0.61488f
C428 a_5894_3600# cmp_clk 0.09135f
C429 a_5894_3600# cmp_q 0.06911f
C430 a_5894_3600# dac_gn[10] 0.0148f
C431 a_5894_3600# dac_gn[11] 0.02626f
C432 a_5894_3600# dac_gn[4] 0.02018f
C433 a_5894_3600# dac_gn[5] 0.2166f
C434 a_5894_3600# dac_gn[6] 0.11119f
C435 a_5894_3600# dac_gn[7] 0.07603f
C436 a_5894_3600# dac_gn[9] 0.171f
C437 a_5894_3600# dac_gp[0] 0.16702f
C438 a_5894_3600# dac_gp[10] 0.05792f
C439 a_5894_3600# dac_gp[11] 0.09436f
C440 a_5894_3600# dac_gp[1] 0.19352f
C441 a_5894_3600# dac_gp[2] 0.15144f
C442 a_5894_3600# dac_gp[3] 0.15294f
C443 a_5894_3600# dac_gp[4] 0.14152f
C444 a_5894_3600# dac_gp[5] 0.51512f
C445 a_5894_3600# dac_gp[6] 0.69495f
C446 a_5894_3600# dac_gp[7] 0.06976f
C447 a_5894_3600# dac_gp[8] 0.06204f
C448 a_5894_3600# dac_gp[9] 0.05836f
C449 a_5894_3600# rst_sw 0.51725f
C450 a_5894_3600# tg_on 0.3246f
C451 a_5894_3600# vdd 1.0353f
C452 a_5894_3600# vdd_dac 2.1829f
C453 a_5894_3600# vin 2.7562f
C454 a_5894_3600# vss 18.817f
C455 a_6494_3600# a_7094_3600# 1.409f
C456 a_6494_3600# a_7694_3600# 0.69359f
C457 a_6494_3600# a_8294_3600# 3.247f
C458 a_6494_3600# a_8894_3600# 2.7382f
C459 a_6494_3600# a_916_7200# 0.13897f
C460 a_6494_3600# a_9494_3600# 0.73512f
C461 a_6494_3600# cmp_clk 0.05945f
C462 a_6494_3600# cmp_q 0.06465f
C463 a_6494_3600# dac_gn[10] 0.02653f
C464 a_6494_3600# dac_gn[11] 0.10484f
C465 a_6494_3600# dac_gn[4] 0.02008f
C466 a_6494_3600# dac_gn[6] 0.2057f
C467 a_6494_3600# dac_gn[7] 0.50063f
C468 a_6494_3600# dac_gn[8] 0.01172f
C469 a_6494_3600# dac_gn[9] 0.18713f
C470 a_6494_3600# dac_gp[0] 0.0552f
C471 a_6494_3600# dac_gp[10] 0.05646f
C472 a_6494_3600# dac_gp[11] 0.08473f
C473 a_6494_3600# dac_gp[1] 0.11409f
C474 a_6494_3600# dac_gp[2] 0.05399f
C475 a_6494_3600# dac_gp[3] 0.05369f
C476 a_6494_3600# dac_gp[4] 0.06244f
C477 a_6494_3600# dac_gp[5] 0.22638f
C478 a_6494_3600# dac_gp[6] 0.15243f
C479 a_6494_3600# dac_gp[7] 0.24746f
C480 a_6494_3600# dac_gp[8] 0.11798f
C481 a_6494_3600# dac_gp[9] 0.07196f
C482 a_6494_3600# rst_sw 0.14245f
C483 a_6494_3600# tg_on 0.27436f
C484 a_6494_3600# vdd 1.4002f
C485 a_6494_3600# vdd_cmp 0.19688f
C486 a_6494_3600# vdd_dac 0.84911f
C487 a_6494_3600# vin 2.9393f
C488 a_6494_3600# vss 5.9095f
C489 a_7094_3600# a_7694_3600# 7.1123f
C490 a_7094_3600# a_8294_3600# 2.3058f
C491 a_7094_3600# a_8894_3600# 1.107f
C492 a_7094_3600# a_916_7200# 0.09361f
C493 a_7094_3600# a_9494_3600# 0.47786f
C494 a_7094_3600# cmp_clk 0.13283f
C495 a_7094_3600# cmp_q 0.07971f
C496 a_7094_3600# dac_gn[10] 0.0148f
C497 a_7094_3600# dac_gn[11] 0.02626f
C498 a_7094_3600# dac_gn[4] 0.0368f
C499 a_7094_3600# dac_gn[7] 0.07684f
C500 a_7094_3600# dac_gn[8] 0.38663f
C501 a_7094_3600# dac_gn[9] 0.17213f
C502 a_7094_3600# dac_gp[0] 0.07418f
C503 a_7094_3600# dac_gp[10] 0.04528f
C504 a_7094_3600# dac_gp[11] 0.04547f
C505 a_7094_3600# dac_gp[1] 0.12421f
C506 a_7094_3600# dac_gp[2] 0.0804f
C507 a_7094_3600# dac_gp[3] 0.12532f
C508 a_7094_3600# dac_gp[4] 0.13649f
C509 a_7094_3600# dac_gp[5] 0.01568f
C510 a_7094_3600# dac_gp[7] 0.48329f
C511 a_7094_3600# dac_gp[8] 0.14724f
C512 a_7094_3600# dac_gp[9] 0.04564f
C513 a_7094_3600# rst_sw 0.17625f
C514 a_7094_3600# tg_on 0.29446f
C515 a_7094_3600# vdd 1.2831f
C516 a_7094_3600# vdd_cmp 0.25606f
C517 a_7094_3600# vdd_dac 0.74932f
C518 a_7094_3600# vin 3.4258f
C519 a_7094_3600# vss 7.0386f
C520 a_7694_3600# a_8294_3600# 8.7463f
C521 a_7694_3600# a_8894_3600# 5.1887f
C522 a_7694_3600# a_916_7200# 0.05581f
C523 a_7694_3600# a_9494_3600# 0.61356f
C524 a_7694_3600# cmp_clk 0.16554f
C525 a_7694_3600# cmp_q 0.08013f
C526 a_7694_3600# dac_gn[10] 0.02247f
C527 a_7694_3600# dac_gn[11] 0.02626f
C528 a_7694_3600# dac_gn[8] 0.07714f
C529 a_7694_3600# dac_gn[9] 0.48664f
C530 a_7694_3600# dac_gp[0] 0.07418f
C531 a_7694_3600# dac_gp[10] 0.05881f
C532 a_7694_3600# dac_gp[11] 0.04742f
C533 a_7694_3600# dac_gp[1] 0.12421f
C534 a_7694_3600# dac_gp[2] 0.11295f
C535 a_7694_3600# dac_gp[3] 0.1388f
C536 a_7694_3600# dac_gp[7] 0.0664f
C537 a_7694_3600# dac_gp[8] 0.55297f
C538 a_7694_3600# dac_gp[9] 0.22383f
C539 a_7694_3600# rst_sw 0.20197f
C540 a_7694_3600# tg_on 0.3473f
C541 a_7694_3600# vdd 0.9493f
C542 a_7694_3600# vdd_cmp 0.26361f
C543 a_7694_3600# vdd_dac 1.6226f
C544 a_7694_3600# vin 1.6136f
C545 a_7694_3600# vss 4.8904f
C546 a_8294_3600# a_8894_3600# 3.8135f
C547 a_8294_3600# a_916_7200# 0.07425f
C548 a_8294_3600# a_9494_3600# 2.379f
C549 a_8294_3600# cmp_clk 0.07372f
C550 a_8294_3600# cmp_q 0.08134f
C551 a_8294_3600# dac_gn[10] 0.3967f
C552 a_8294_3600# dac_gn[11] 0.02937f
C553 a_8294_3600# dac_gn[9] 0.07773f
C554 a_8294_3600# dac_gp[0] 0.08637f
C555 a_8294_3600# dac_gp[10] 0.1614f
C556 a_8294_3600# dac_gp[11] 0.0594f
C557 a_8294_3600# dac_gp[1] 0.14948f
C558 a_8294_3600# dac_gp[2] 0.12077f
C559 a_8294_3600# dac_gp[8] 0.42836f
C560 a_8294_3600# dac_gp[9] 0.60511f
C561 a_8294_3600# rst_sw 1.0686f
C562 a_8294_3600# tg_on 0.41313f
C563 a_8294_3600# vdd 2.0394f
C564 a_8294_3600# vdd_cmp 0.18061f
C565 a_8294_3600# vdd_dac 1.6999f
C566 a_8294_3600# vin 1.8371f
C567 a_8294_3600# vss 8.8663f
C568 a_8894_3600# a_916_7200# 0.21302f
C569 a_8894_3600# a_9494_3600# 10.161f
C570 a_8894_3600# cmp_clk 0.1433f
C571 a_8894_3600# cmp_q 0.08056f
C572 a_8894_3600# dac_gn[10] 0.09248f
C573 a_8894_3600# dac_gn[11] 0.41649f
C574 a_8894_3600# dac_gp[0] 0.18993f
C575 a_8894_3600# dac_gp[10] 0.5071f
C576 a_8894_3600# dac_gp[11] 0.23344f
C577 a_8894_3600# dac_gp[1] 0.04013f
C578 a_8894_3600# rst_sw 1.0083f
C579 a_8894_3600# tg_on 0.30778f
C580 a_8894_3600# vdd 0.94613f
C581 a_8894_3600# vdd_dac 0.75083f
C582 a_8894_3600# vin 1.6158f
C583 a_8894_3600# vss 10.734f
C584 a_916_7200# a_9494_3600# 0.89565f
C585 a_916_7200# rst_sw 0.70179f
C586 a_916_7200# tg_on 0.64981f
C587 a_916_7200# vdd 1.7471f
C588 a_916_7200# vdd_cmp 0.02965f
C589 a_916_7200# vdd_dac 0.08603f
C590 a_916_7200# vin 0.12441f
C591 a_916_7200# vss 26.818f
C592 a_9494_3600# cmp_clk 0.39477f
C593 a_9494_3600# cmp_q 0.17655f
C594 a_9494_3600# dac_gn[11] 0.08568f
C595 a_9494_3600# dac_gp[0] 0.04745f
C596 a_9494_3600# dac_gp[11] 0.57778f
C597 a_9494_3600# rst_sw 0.29577f
C598 a_9494_3600# tg_on 1.3164f
C599 a_9494_3600# vdd 1.4525f
C600 a_9494_3600# vdd_cmp 0.42088f
C601 a_9494_3600# vdd_dac 3.7975f
C602 a_9494_3600# vin 0.72587f
C603 a_9494_3600# vss 19.682f
C604 cmp_clk cmp_q 10.526f
C605 cmp_clk dac_gdn 0.02449f
C606 cmp_clk dac_gn[0] 0.20831f
C607 cmp_clk dac_gp[0] 0.0607f
C608 cmp_clk dac_gp[10] 0.06353f
C609 cmp_clk dac_gp[11] 0.10935f
C610 cmp_clk dac_gp[1] 0.06656f
C611 cmp_clk dac_gp[2] 0.44355f
C612 cmp_clk dac_gp[3] 0.22621f
C613 cmp_clk dac_gp[4] 0.06882f
C614 cmp_clk dac_gp[5] 0.1061f
C615 cmp_clk dac_gp[6] 0.06694f
C616 cmp_clk dac_gp[7] 0.07605f
C617 cmp_clk dac_gp[8] 0.07114f
C618 cmp_clk dac_gp[9] 0.06357f
C619 cmp_clk rst_sw 0.32025f
C620 cmp_clk tg_on 0.20545f
C621 cmp_clk vdd 0.25435f
C622 cmp_clk vdd_cmp 4.9976f
C623 cmp_clk vdd_dac 6.2886f
C624 cmp_clk vin 0.14307f
C625 cmp_clk vss 5.7119f
C626 cmp_q dac_gn[0] 0.08092f
C627 cmp_q dac_gn[1] 0.72105f
C628 cmp_q dac_gp[0] 0.28236f
C629 cmp_q dac_gp[10] 0.05123f
C630 cmp_q dac_gp[11] 0.27608f
C631 cmp_q dac_gp[1] 0.06735f
C632 cmp_q dac_gp[2] 0.49209f
C633 cmp_q dac_gp[3] 0.32103f
C634 cmp_q dac_gp[4] 0.61522f
C635 cmp_q dac_gp[5] 0.1441f
C636 cmp_q dac_gp[6] 1.8496f
C637 cmp_q dac_gp[7] 0.06206f
C638 cmp_q dac_gp[8] 0.05862f
C639 cmp_q dac_gp[9] 0.05123f
C640 cmp_q rst_sw 0.10867f
C641 cmp_q tg_on 0.27546f
C642 cmp_q vdd 0.60609f
C643 cmp_q vdd_cmp 3.0537f
C644 cmp_q vdd_dac 0.0838f
C645 cmp_q vin 0.13874f
C646 cmp_q vss 7.171f
C647 dac_gdn dac_gn[0] 0.04487f
C648 dac_gdn rst_sw 0.10778f
C649 dac_gdn tg_on 0.46519f
C650 dac_gdn vin 0.36064f
C651 dac_gdn vss 1.3327f
C652 dac_gn[0] dac_gn[10] 0.10435f
C653 dac_gn[0] dac_gn[11] 0.09242f
C654 dac_gn[0] dac_gn[1] 0.24053f
C655 dac_gn[0] dac_gn[2] 0.4712f
C656 dac_gn[0] dac_gn[3] 0.35045f
C657 dac_gn[0] dac_gn[4] 1.1198f
C658 dac_gn[0] dac_gn[5] 0.08631f
C659 dac_gn[0] dac_gn[6] 0.10592f
C660 dac_gn[0] dac_gn[7] 0.13036f
C661 dac_gn[0] dac_gn[8] 0.07316f
C662 dac_gn[0] dac_gn[9] 0.15423f
C663 dac_gn[0] dac_gp[0] 0.18438f
C664 dac_gn[0] dac_gp[10] 0.12566f
C665 dac_gn[0] dac_gp[11] 0.1385f
C666 dac_gn[0] dac_gp[1] 0.34126f
C667 dac_gn[0] dac_gp[2] 0.10709f
C668 dac_gn[0] dac_gp[3] 0.16727f
C669 dac_gn[0] dac_gp[4] 0.219f
C670 dac_gn[0] dac_gp[5] 0.219f
C671 dac_gn[0] dac_gp[6] 0.10447f
C672 dac_gn[0] dac_gp[7] 0.91107f
C673 dac_gn[0] dac_gp[8] 0.05731f
C674 dac_gn[0] dac_gp[9] 0.33763f
C675 dac_gn[0] tg_on 0.32795f
C676 dac_gn[0] vin 0.66551f
C677 dac_gn[0] vss 6.345f
C678 dac_gn[10] dac_gn[11] 3.5522f
C679 dac_gn[10] dac_gn[1] 0.08684f
C680 dac_gn[10] dac_gn[2] 0.21793f
C681 dac_gn[10] dac_gn[3] 0.30294f
C682 dac_gn[10] dac_gn[4] 0.07778f
C683 dac_gn[10] dac_gn[5] 0.0691f
C684 dac_gn[10] dac_gn[6] 0.06515f
C685 dac_gn[10] dac_gn[7] 0.06037f
C686 dac_gn[10] dac_gn[8] 1.7232f
C687 dac_gn[10] dac_gn[9] 0.42748f
C688 dac_gn[10] dac_gp[0] 0.08463f
C689 dac_gn[10] dac_gp[10] 0.58256f
C690 dac_gn[10] dac_gp[1] 0.17435f
C691 dac_gn[10] dac_gp[2] 0.11169f
C692 dac_gn[10] dac_gp[3] 0.07491f
C693 dac_gn[10] dac_gp[4] 0.06164f
C694 dac_gn[10] dac_gp[5] 0.05143f
C695 dac_gn[10] dac_gp[6] 0.06395f
C696 dac_gn[10] dac_gp[7] 0.21955f
C697 dac_gn[10] dac_gp[8] 0.0532f
C698 dac_gn[10] dac_gp[9] 0.09848f
C699 dac_gn[10] tg_on 0.28757f
C700 dac_gn[10] vin 0.25189f
C701 dac_gn[10] vss 0.91478f
C702 dac_gn[11] dac_gn[1] 0.15871f
C703 dac_gn[11] dac_gn[2] 0.29365f
C704 dac_gn[11] dac_gn[3] 0.05607f
C705 dac_gn[11] dac_gn[4] 0.0581f
C706 dac_gn[11] dac_gn[5] 0.06881f
C707 dac_gn[11] dac_gn[6] 0.05547f
C708 dac_gn[11] dac_gn[7] 0.04787f
C709 dac_gn[11] dac_gn[8] 0.06709f
C710 dac_gn[11] dac_gn[9] 0.06991f
C711 dac_gn[11] dac_gp[0] 0.47657f
C712 dac_gn[11] dac_gp[10] 0.16571f
C713 dac_gn[11] dac_gp[11] 0.50839f
C714 dac_gn[11] dac_gp[1] 4.1397f
C715 dac_gn[11] dac_gp[2] 0.06445f
C716 dac_gn[11] dac_gp[3] 0.06424f
C717 dac_gn[11] dac_gp[4] 0.06178f
C718 dac_gn[11] dac_gp[5] 0.0583f
C719 dac_gn[11] dac_gp[6] 0.06379f
C720 dac_gn[11] dac_gp[7] 0.05591f
C721 dac_gn[11] dac_gp[8] 0.05619f
C722 dac_gn[11] dac_gp[9] 0.04523f
C723 dac_gn[11] tg_on 0.28713f
C724 dac_gn[11] vin 0.75483f
C725 dac_gn[11] vss 0.85782f
C726 dac_gn[1] dac_gn[2] 3.7685f
C727 dac_gn[1] dac_gn[3] 0.07194f
C728 dac_gn[1] dac_gn[4] 0.06764f
C729 dac_gn[1] dac_gn[5] 0.04349f
C730 dac_gn[1] dac_gn[6] 0.07115f
C731 dac_gn[1] dac_gn[7] 0.07191f
C732 dac_gn[1] dac_gn[8] 0.07373f
C733 dac_gn[1] dac_gn[9] 0.05197f
C734 dac_gn[1] dac_gp[0] 0.08825f
C735 dac_gn[1] dac_gp[10] 0.07001f
C736 dac_gn[1] dac_gp[11] 0.21876f
C737 dac_gn[1] dac_gp[1] 0.23573f
C738 dac_gn[1] dac_gp[2] 0.06925f
C739 dac_gn[1] dac_gp[3] 0.07646f
C740 dac_gn[1] dac_gp[4] 0.07801f
C741 dac_gn[1] dac_gp[5] 0.07801f
C742 dac_gn[1] dac_gp[6] 0.06925f
C743 dac_gn[1] dac_gp[7] 0.04746f
C744 dac_gn[1] dac_gp[8] 0.0781f
C745 dac_gn[1] dac_gp[9] 0.07702f
C746 dac_gn[1] tg_on 0.1596f
C747 dac_gn[1] vin 0.18519f
C748 dac_gn[1] vss 2.8738f
C749 dac_gn[2] dac_gn[3] 2.8471f
C750 dac_gn[2] dac_gn[4] 0.06351f
C751 dac_gn[2] dac_gn[5] 0.04615f
C752 dac_gn[2] dac_gn[6] 0.06445f
C753 dac_gn[2] dac_gn[7] 0.06553f
C754 dac_gn[2] dac_gn[8] 0.06731f
C755 dac_gn[2] dac_gn[9] 0.05198f
C756 dac_gn[2] dac_gp[0] 0.06882f
C757 dac_gn[2] dac_gp[10] 0.46593f
C758 dac_gn[2] dac_gp[11] 0.05714f
C759 dac_gn[2] dac_gp[1] 0.11983f
C760 dac_gn[2] dac_gp[2] 0.13569f
C761 dac_gn[2] dac_gp[3] 0.06318f
C762 dac_gn[2] dac_gp[4] 0.05685f
C763 dac_gn[2] dac_gp[5] 0.05548f
C764 dac_gn[2] dac_gp[6] 0.07444f
C765 dac_gn[2] dac_gp[7] 0.20176f
C766 dac_gn[2] dac_gp[8] 0.05552f
C767 dac_gn[2] dac_gp[9] 0.05942f
C768 dac_gn[2] tg_on 0.16292f
C769 dac_gn[2] vin 0.18881f
C770 dac_gn[2] vss 0.90147f
C771 dac_gn[3] dac_gn[4] 0.16983f
C772 dac_gn[3] dac_gn[5] 0.99863f
C773 dac_gn[3] dac_gn[6] 0.06445f
C774 dac_gn[3] dac_gn[7] 0.06635f
C775 dac_gn[3] dac_gn[8] 0.44544f
C776 dac_gn[3] dac_gn[9] 0.11883f
C777 dac_gn[3] dac_gp[0] 0.05584f
C778 dac_gn[3] dac_gp[10] 0.51534f
C779 dac_gn[3] dac_gp[1] 0.0501f
C780 dac_gn[3] dac_gp[2] 0.08518f
C781 dac_gn[3] dac_gp[3] 0.14082f
C782 dac_gn[3] dac_gp[4] 0.06482f
C783 dac_gn[3] dac_gp[5] 0.05628f
C784 dac_gn[3] dac_gp[6] 0.06331f
C785 dac_gn[3] dac_gp[7] 0.53432f
C786 dac_gn[3] dac_gp[8] 0.08207f
C787 dac_gn[3] dac_gp[9] 0.16876f
C788 dac_gn[3] tg_on 0.1616f
C789 dac_gn[3] vin 0.17666f
C790 dac_gn[3] vss 0.96432f
C791 dac_gn[4] dac_gn[5] 0.26124f
C792 dac_gn[4] dac_gn[6] 0.07537f
C793 dac_gn[4] dac_gn[7] 0.71774f
C794 dac_gn[4] dac_gn[8] 0.20252f
C795 dac_gn[4] dac_gn[9] 0.51052f
C796 dac_gn[4] dac_gp[0] 0.05189f
C797 dac_gn[4] dac_gp[10] 0.47057f
C798 dac_gn[4] dac_gp[1] 0.05046f
C799 dac_gn[4] dac_gp[3] 0.15302f
C800 dac_gn[4] dac_gp[4] 0.14367f
C801 dac_gn[4] dac_gp[5] 0.07019f
C802 dac_gn[4] dac_gp[6] 0.07276f
C803 dac_gn[4] dac_gp[9] 0.01941f
C804 dac_gn[4] tg_on 0.16979f
C805 dac_gn[4] vin 0.19626f
C806 dac_gn[4] vss 1.9018f
C807 dac_gn[5] dac_gn[6] 0.06449f
C808 dac_gn[5] dac_gn[7] 0.17101f
C809 dac_gn[5] dac_gn[8] 1.0341f
C810 dac_gn[5] dac_gn[9] 0.09571f
C811 dac_gn[5] dac_gp[0] 0.07266f
C812 dac_gn[5] dac_gp[1] 0.06396f
C813 dac_gn[5] dac_gp[4] 0.29793f
C814 dac_gn[5] dac_gp[5] 0.34755f
C815 dac_gn[5] dac_gp[6] 0.10749f
C816 dac_gn[5] tg_on 0.1649f
C817 dac_gn[5] vin 0.17814f
C818 dac_gn[5] vss 0.67069f
C819 dac_gn[6] dac_gn[7] 0.11061f
C820 dac_gn[6] dac_gn[8] 0.06429f
C821 dac_gn[6] dac_gn[9] 0.08351f
C822 dac_gn[6] dac_gp[0] 0.07592f
C823 dac_gn[6] dac_gp[1] 0.06246f
C824 dac_gn[6] dac_gp[5] 0.08085f
C825 dac_gn[6] dac_gp[6] 0.2321f
C826 dac_gn[6] tg_on 0.16031f
C827 dac_gn[6] vin 0.19511f
C828 dac_gn[6] vss 0.64924f
C829 dac_gn[7] dac_gn[8] 0.2303f
C830 dac_gn[7] dac_gn[9] 0.7332f
C831 dac_gn[7] dac_gp[0] 0.06362f
C832 dac_gn[7] dac_gp[1] 0.05342f
C833 dac_gn[7] dac_gp[4] 0.02949f
C834 dac_gn[7] dac_gp[5] 0.38166f
C835 dac_gn[7] dac_gp[6] 0.19326f
C836 dac_gn[7] dac_gp[7] 0.02616f
C837 dac_gn[7] tg_on 0.28492f
C838 dac_gn[7] vin 0.19722f
C839 dac_gn[7] vss 0.85735f
C840 dac_gn[8] dac_gn[9] 0.12787f
C841 dac_gn[8] dac_gp[0] 0.07772f
C842 dac_gn[8] dac_gp[1] 0.06246f
C843 dac_gn[8] dac_gp[3] 0.13893f
C844 dac_gn[8] dac_gp[4] 0.12241f
C845 dac_gn[8] dac_gp[5] 0.05123f
C846 dac_gn[8] dac_gp[6] 0.06266f
C847 dac_gn[8] dac_gp[7] 0.12361f
C848 dac_gn[8] dac_gp[8] 0.06612f
C849 dac_gn[8] tg_on 0.27898f
C850 dac_gn[8] vin 0.18155f
C851 dac_gn[8] vss 0.81432f
C852 dac_gn[9] dac_gp[0] 0.07772f
C853 dac_gn[9] dac_gp[10] 0.11142f
C854 dac_gn[9] dac_gp[1] 0.06246f
C855 dac_gn[9] dac_gp[2] 0.11846f
C856 dac_gn[9] dac_gp[3] 0.11252f
C857 dac_gn[9] dac_gp[4] 0.07058f
C858 dac_gn[9] dac_gp[5] 0.0581f
C859 dac_gn[9] dac_gp[6] 0.0674f
C860 dac_gn[9] dac_gp[7] 0.08349f
C861 dac_gn[9] dac_gp[8] 0.48335f
C862 dac_gn[9] dac_gp[9] 0.32457f
C863 dac_gn[9] tg_on 0.37395f
C864 dac_gn[9] vin 2.8154f
C865 dac_gn[9] vss 1.1575f
C866 dac_gp[0] dac_gp[10] 0.04457f
C867 dac_gp[0] dac_gp[11] 0.06302f
C868 dac_gp[0] dac_gp[1] 6.1737f
C869 dac_gp[0] dac_gp[2] 4.3235f
C870 dac_gp[0] dac_gp[3] 0.06274f
C871 dac_gp[0] dac_gp[4] 0.06172f
C872 dac_gp[0] dac_gp[5] 0.05189f
C873 dac_gp[0] dac_gp[6] 0.06266f
C874 dac_gp[0] dac_gp[7] 0.0554f
C875 dac_gp[0] dac_gp[8] 0.08075f
C876 dac_gp[0] dac_gp[9] 0.04457f
C877 dac_gp[0] rst_sw 0.07974f
C878 dac_gp[0] tg_on 0.49905f
C879 dac_gp[0] vdd_dac 0.59997f
C880 dac_gp[0] vin 0.19915f
C881 dac_gp[0] vss 1.1248f
C882 dac_gp[10] dac_gp[11] 0.12328f
C883 dac_gp[10] dac_gp[1] 0.04457f
C884 dac_gp[10] dac_gp[2] 0.05123f
C885 dac_gp[10] dac_gp[3] 0.05199f
C886 dac_gp[10] dac_gp[4] 0.05123f
C887 dac_gp[10] dac_gp[5] 0.05204f
C888 dac_gp[10] dac_gp[6] 0.05123f
C889 dac_gp[10] dac_gp[7] 0.06917f
C890 dac_gp[10] dac_gp[8] 0.05534f
C891 dac_gp[10] dac_gp[9] 1.6247f
C892 dac_gp[10] rst_sw 0.06436f
C893 dac_gp[10] tg_on 0.05685f
C894 dac_gp[10] vdd_dac 0.48763f
C895 dac_gp[10] vin 0.06803f
C896 dac_gp[10] vss 0.37539f
C897 dac_gp[11] dac_gp[1] 0.06745f
C898 dac_gp[11] dac_gp[2] 0.06453f
C899 dac_gp[11] dac_gp[3] 0.09927f
C900 dac_gp[11] dac_gp[4] 0.1605f
C901 dac_gp[11] dac_gp[5] 1.3264f
C902 dac_gp[11] dac_gp[6] 0.06322f
C903 dac_gp[11] dac_gp[7] 0.07146f
C904 dac_gp[11] dac_gp[8] 0.06724f
C905 dac_gp[11] dac_gp[9] 0.05818f
C906 dac_gp[11] rst_sw 0.59254f
C907 dac_gp[11] tg_on 0.10625f
C908 dac_gp[11] vdd_dac 0.56777f
C909 dac_gp[11] vin 0.07856f
C910 dac_gp[11] vss 0.95205f
C911 dac_gp[1] dac_gp[2] 0.15721f
C912 dac_gp[1] dac_gp[3] 0.05372f
C913 dac_gp[1] dac_gp[4] 0.05123f
C914 dac_gp[1] dac_gp[5] 0.0516f
C915 dac_gp[1] dac_gp[6] 0.05362f
C916 dac_gp[1] dac_gp[7] 0.05362f
C917 dac_gp[1] dac_gp[8] 0.04883f
C918 dac_gp[1] dac_gp[9] 0.04457f
C919 dac_gp[1] rst_sw 0.07269f
C920 dac_gp[1] tg_on 0.1317f
C921 dac_gp[1] vdd_dac 0.50603f
C922 dac_gp[1] vin 0.26996f
C923 dac_gp[1] vss 0.81768f
C924 dac_gp[2] dac_gp[3] 0.35968f
C925 dac_gp[2] dac_gp[4] 2.914f
C926 dac_gp[2] dac_gp[5] 0.05933f
C927 dac_gp[2] dac_gp[6] 0.06589f
C928 dac_gp[2] dac_gp[7] 0.06206f
C929 dac_gp[2] dac_gp[8] 0.06641f
C930 dac_gp[2] dac_gp[9] 0.05123f
C931 dac_gp[2] rst_sw 0.08442f
C932 dac_gp[2] tg_on 0.67241f
C933 dac_gp[2] vdd_dac 0.56547f
C934 dac_gp[2] vin 0.1537f
C935 dac_gp[2] vss 0.70138f
C936 dac_gp[3] dac_gp[4] 0.50749f
C937 dac_gp[3] dac_gp[5] 2.2777f
C938 dac_gp[3] dac_gp[6] 0.07353f
C939 dac_gp[3] dac_gp[7] 0.06528f
C940 dac_gp[3] dac_gp[8] 0.0637f
C941 dac_gp[3] dac_gp[9] 0.05199f
C942 dac_gp[3] rst_sw 0.25797f
C943 dac_gp[3] tg_on 3.2277f
C944 dac_gp[3] vdd_dac 0.55855f
C945 dac_gp[3] vin 0.14168f
C946 dac_gp[3] vss 3.2207f
C947 dac_gp[4] dac_gp[5] 0.57709f
C948 dac_gp[4] dac_gp[6] 1.863f
C949 dac_gp[4] dac_gp[7] 0.06206f
C950 dac_gp[4] dac_gp[8] 0.06078f
C951 dac_gp[4] dac_gp[9] 0.05123f
C952 dac_gp[4] rst_sw 0.07532f
C953 dac_gp[4] tg_on 0.08164f
C954 dac_gp[4] vdd_dac 0.52357f
C955 dac_gp[4] vin 0.14506f
C956 dac_gp[4] vss 0.57937f
C957 dac_gp[5] dac_gp[6] 0.65759f
C958 dac_gp[5] dac_gp[7] 0.06533f
C959 dac_gp[5] dac_gp[8] 0.06182f
C960 dac_gp[5] dac_gp[9] 0.05204f
C961 dac_gp[5] rst_sw 0.36953f
C962 dac_gp[5] tg_on 0.06505f
C963 dac_gp[5] vdd 0.01388f
C964 dac_gp[5] vdd_dac 0.56838f
C965 dac_gp[5] vin 0.11833f
C966 dac_gp[5] vss 1.6095f
C967 dac_gp[6] dac_gp[7] 0.09327f
C968 dac_gp[6] dac_gp[8] 0.0592f
C969 dac_gp[6] dac_gp[9] 0.05123f
C970 dac_gp[6] rst_sw 0.06953f
C971 dac_gp[6] tg_on 0.10623f
C972 dac_gp[6] vdd 0.01161f
C973 dac_gp[6] vdd_dac 0.50818f
C974 dac_gp[6] vin 0.11935f
C975 dac_gp[6] vss 0.40599f
C976 dac_gp[7] dac_gp[8] 0.37035f
C977 dac_gp[7] dac_gp[9] 0.19276f
C978 dac_gp[7] rst_sw 0.08212f
C979 dac_gp[7] tg_on 0.07225f
C980 dac_gp[7] vdd_dac 0.60791f
C981 dac_gp[7] vin 0.07516f
C982 dac_gp[7] vss 1.006f
C983 dac_gp[8] dac_gp[9] 0.90663f
C984 dac_gp[8] rst_sw 0.0775f
C985 dac_gp[8] tg_on 0.13296f
C986 dac_gp[8] vdd_dac 0.55916f
C987 dac_gp[8] vin 0.06309f
C988 dac_gp[8] vss 0.41543f
C989 dac_gp[9] rst_sw 0.06561f
C990 dac_gp[9] tg_on 0.06604f
C991 dac_gp[9] vdd_dac 0.52609f
C992 dac_gp[9] vin 0.09485f
C993 dac_gp[9] vss 0.49613f
C994 rst_sw tg_on 0.40556f
C995 rst_sw vdd 2.3393f
C996 rst_sw vdd_dac 3.2042f
C997 rst_sw vin 0.68001f
C998 rst_sw vss 5.9493f
C999 tg_on vdd 1.001f
C1000 tg_on vdd_cmp 1.1724f
C1001 tg_on vdd_dac 0.10391f
C1002 tg_on vin 2.917f
C1003 tg_on vss 15.188f
C1004 vdd vdd_cmp 7.6924f
C1005 vdd vdd_dac 2.0194f
C1006 vdd vin 4.3594f
C1007 vdd vss 125.2f
C1008 vdd_cmp vdd_dac 0.87089f
C1009 vdd_cmp vss 192.25f
C1010 vdd_dac vin 0.07873f
C1011 vdd_dac vss 69.606f
C1012 vin vss 7.7474f
.ends
