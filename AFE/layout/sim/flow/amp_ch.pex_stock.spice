* NGSPICE file created from amp_ch (flattened) - technology: gf180mcuD

.subckt amp_ch rec ref vbn vcm vg1 vcmo vg2 vrs out sw_rec sw_rec_b rst_amp
+ vdd vss
X0 w_6420_25696# a_6838_13302# vss vss nfet_03v3 ad=13p pd=50.52u as=13p ps=50.52u w=50u l=16u
X1 vss vbn a_21038_6704# vss nfet_03v3 ad=4.16p pd=16.52u as=4.16p ps=16.52u w=16u l=4u
X2 a_2255_26003# a_2135_25448# a_2067_26003# vdd pfet_05v0 ad=0.1469p pd=1.085u as=0.2486p ps=2.01u w=0.565u l=0.5u
X3 a_21038_6704# vbn vss vss nfet_03v3 ad=4.16p pd=16.52u as=4.16p ps=16.52u w=16u l=4u
X4 a_1508_13302# w_5020_25696# a_1438_1244# vdd pfet_03v3 ad=13p pd=50.52u as=13p ps=50.52u w=50u l=2u
X5 a_40438_43940# sw_rec a_40316_41200# vss nfet_03v3 ad=0.61p pd=3.22u as=0.61p ps=3.22u w=1u l=0.5u
X6 a_5238_25664# a_2731_25872# vrs vss nfet_03v3 ad=0.305p pd=2.22u as=0.305p ps=2.22u w=0.5u l=0.5u
X7 a_21038_6704# vbn vss vss nfet_03v3 ad=4.16p pd=16.52u as=4.16p ps=16.52u w=16u l=4u
X8 vss vbn a_21038_6704# vss nfet_03v3 ad=4.16p pd=16.52u as=4.16p ps=16.52u w=16u l=4u
X9 a_1438_1244# w_5020_25696# a_1508_13302# vdd pfet_03v3 ad=13p pd=50.52u as=13p ps=50.52u w=50u l=2u
X10 a_1438_1244# w_5020_25696# a_1508_13302# vdd pfet_03v3 ad=13p pd=50.52u as=32.5p ps=0.1013m w=50u l=2u
X11 a_1508_13302# a_21038_6704# vdd vdd pfet_03v3 ad=13p pd=50.52u as=13p ps=50.52u w=50u l=4u
X12 vss vbn a_21038_6704# vss nfet_03v3 ad=9.76p pd=33.22u as=4.16p ps=16.52u w=16u l=4u
X13 out vbn vss vss nfet_03v3 ad=4.16p pd=16.52u as=9.76p ps=33.22u w=16u l=4u
X14 a_40138_40000# a_14738_25200# w_39820_39896# w_39820_39896# pfet_03v3 ad=0.2166p pd=2.06u as=0.2166p ps=2.06u w=0.22u l=0.5u
X15 vdd a_28022_1954# out vss nfet_06v0_nvt ad=5.7p pd=21.14u as=5.7p ps=21.14u w=10u l=2u
X16 a_6838_13302# a_1438_1244# vss vss nfet_03v3 ad=30.5p pd=0.10122m as=30.5p ps=0.10122m w=50u l=16u
X17 vss vbn a_21038_6704# vss nfet_03v3 ad=4.16p pd=16.52u as=4.16p ps=16.52u w=16u l=4u
X18 w_5020_25696# rec cap_mim_2f0_m4m5_noshield c_width=61.15u c_length=61.15u
X19 a_6838_13302# w_28620_25696# a_1508_13302# vdd pfet_03v3 ad=13p pd=50.52u as=13p ps=50.52u w=50u l=2u
X20 a_6838_13302# w_28620_25696# a_1508_13302# vdd pfet_03v3 ad=13p pd=50.52u as=32.5p ps=0.1013m w=50u l=2u
X21 a_1508_13302# w_28620_25696# a_6838_13302# vdd pfet_03v3 ad=13p pd=50.52u as=13p ps=50.52u w=50u l=2u
X22 vss vbn a_21038_6704# vss nfet_03v3 ad=4.16p pd=16.52u as=4.16p ps=16.52u w=16u l=4u
X23 rec sw_rec_b vcm vss nfet_03v3 ad=0.61p pd=3.22u as=0.61p ps=3.22u w=1u l=0.5u
X24 a_21038_6704# vbn vss vss nfet_03v3 ad=4.16p pd=16.52u as=4.16p ps=16.52u w=16u l=4u
X25 vdd a_21038_6704# a_21038_6704# vdd pfet_03v3 ad=13p pd=50.52u as=13p ps=50.52u w=50u l=4u
X26 a_28022_1954# w_39820_39896# a_36238_23200# vss nfet_03v3 ad=0.305p pd=2.22u as=0.305p ps=2.22u w=0.5u l=40u
X27 a_6838_13302# w_28620_25696# a_1508_13302# vdd pfet_03v3 ad=13p pd=50.52u as=13p ps=50.52u w=50u l=2u
X28 a_6838_13302# w_28620_25696# a_1508_13302# vdd pfet_03v3 ad=13p pd=50.52u as=32.5p ps=0.1013m w=50u l=2u
X29 a_5338_25800# a_5238_25664# w_5020_25696# w_5020_25696# pfet_03v3 ad=0.2166p pd=2.06u as=0.2166p ps=2.06u w=0.22u l=0.5u
X30 a_1508_13302# w_28620_25696# a_6838_13302# vdd pfet_03v3 ad=13p pd=50.52u as=13p ps=50.52u w=50u l=2u
X31 a_1508_13302# w_28620_25696# a_6838_13302# vdd pfet_03v3 ad=13p pd=50.52u as=13p ps=50.52u w=50u l=2u
X32 a_40238_24600# sw_rec vdd vdd pfet_03v3 ad=0.65p pd=3.3u as=0.65p ps=3.3u w=1u l=0.5u
X33 a_21038_6704# vbn vss vss nfet_03v3 ad=4.16p pd=16.52u as=4.16p ps=16.52u w=16u l=4u
X34 vss vbn a_21038_6704# vss nfet_03v3 ad=4.16p pd=16.52u as=4.16p ps=16.52u w=16u l=4u
X35 a_21038_6704# vbn vss vss nfet_03v3 ad=4.16p pd=16.52u as=4.16p ps=16.52u w=16u l=4u
X36 w_39820_39896# out cap_mim_2f0_m4m5_noshield c_width=11.92u c_length=11.92u
X37 w_28620_25696# ref cap_mim_2f0_m4m5_noshield c_width=61.15u c_length=61.15u
X38 a_1438_1244# w_5020_25696# a_1508_13302# vdd pfet_03v3 ad=13p pd=50.52u as=13p ps=50.52u w=50u l=2u
X39 a_1438_1244# w_5020_25696# a_1508_13302# vdd pfet_03v3 ad=13p pd=50.52u as=32.5p ps=0.1013m w=50u l=2u
X40 a_6838_13302# a_1438_1244# vss vss nfet_03v3 ad=30.5p pd=0.10122m as=30.5p ps=0.10122m w=50u l=16u
X41 a_40238_24600# vbn vss vss nfet_03v3 ad=0.2128p pd=1.98u as=0.2128p ps=1.98u w=0.28u l=40u
X42 a_1508_13302# w_5020_25696# a_1438_1244# vdd pfet_03v3 ad=32.5p pd=0.1013m as=13p ps=50.52u w=50u l=2u
X43 a_1508_13302# w_5020_25696# a_1438_1244# vdd pfet_03v3 ad=13p pd=50.52u as=13p ps=50.52u w=50u l=2u
X44 a_1508_13302# w_28620_25696# a_6838_13302# vdd pfet_03v3 ad=13p pd=50.52u as=13p ps=50.52u w=50u l=2u
X45 w_6420_25696# a_6838_13302# vss vss nfet_03v3 ad=13p pd=50.52u as=30.5p ps=0.10122m w=50u l=16u
X46 a_2731_25872# a_2067_26003# vdd vdd pfet_05v0 ad=0.5368p pd=3.32u as=0.38705p ps=2.08u w=1.22u l=0.5u
X47 w_28620_25696# ref cap_mim_2f0_m4m5_noshield c_width=61.15u c_length=61.15u
X48 a_5238_25664# a_2731_25872# vg1 vdd pfet_03v3 ad=0.325p pd=2.3u as=0.325p ps=2.3u w=0.5u l=0.5u
X49 w_39820_39896# w_6420_25696# cap_mim_2f0_m4m5_noshield c_width=38.59u c_length=38.59u
X50 vss vbn a_21038_6704# vss nfet_03v3 ad=4.16p pd=16.52u as=4.16p ps=16.52u w=16u l=4u
X51 a_21038_6704# vbn vss vss nfet_03v3 ad=4.16p pd=16.52u as=4.16p ps=16.52u w=16u l=4u
X52 a_1508_13302# w_5020_25696# a_1438_1244# vdd pfet_03v3 ad=13p pd=50.52u as=13p ps=50.52u w=50u l=2u
X53 a_1508_13302# w_5020_25696# a_1438_1244# vdd pfet_03v3 ad=13p pd=50.52u as=13p ps=50.52u w=50u l=2u
X54 a_1438_1244# w_5020_25696# a_1508_13302# vdd pfet_03v3 ad=13p pd=50.52u as=13p ps=50.52u w=50u l=2u
X55 a_21038_6704# vbn vss vss nfet_03v3 ad=4.16p pd=16.52u as=4.16p ps=16.52u w=16u l=4u
X56 a_6838_13302# w_28620_25696# a_1508_13302# vdd pfet_03v3 ad=13p pd=50.52u as=13p ps=50.52u w=50u l=2u
X57 vss vbn out vss nfet_03v3 ad=4.16p pd=16.52u as=4.16p ps=16.52u w=16u l=4u
X58 a_2135_25448# a_40438_43940# vdd vdd pfet_03v3 ad=1.3p pd=5.3u as=1.3p ps=5.3u w=2u l=0.5u
X59 a_1508_13302# w_28620_25696# a_6838_13302# vdd pfet_03v3 ad=32.5p pd=0.1013m as=13p ps=50.52u w=50u l=2u
X60 w_5020_25696# rec cap_mim_2f0_m4m5_noshield c_width=61.15u c_length=61.15u
X61 vss vbn a_21038_6704# vss nfet_03v3 ad=4.16p pd=16.52u as=4.16p ps=16.52u w=16u l=4u
X62 a_21038_6704# vbn vss vss nfet_03v3 ad=4.16p pd=16.52u as=4.16p ps=16.52u w=16u l=4u
X63 a_2067_26003# a_2135_25448# vss vss nfet_05v0 ad=93.59999f pd=0.88u as=0.1584p ps=1.6u w=0.36u l=0.6u
X64 vss a_6838_13302# w_6420_25696# vss nfet_03v3 ad=30.5p pd=0.10122m as=13p ps=50.52u w=50u l=16u
X65 vss vbn a_21038_6704# vss nfet_03v3 ad=4.16p pd=16.52u as=4.16p ps=16.52u w=16u l=4u
X66 vss a_6838_13302# w_6420_25696# vss nfet_03v3 ad=13p pd=50.52u as=13p ps=50.52u w=50u l=16u
X67 vdd a_21038_6704# w_6420_25696# vdd pfet_03v3 ad=32.5p pd=0.1013m as=13p ps=50.52u w=50u l=4u
X68 a_6838_13302# w_28620_25696# a_1508_13302# vdd pfet_03v3 ad=13p pd=50.52u as=13p ps=50.52u w=50u l=2u
X69 a_36238_23200# vbn vss vss nfet_03v3 ad=0.61p pd=3.22u as=0.61p ps=3.22u w=1u l=20u
X70 a_1508_13302# w_28620_25696# a_6838_13302# vdd pfet_03v3 ad=32.5p pd=0.1013m as=13p ps=50.52u w=50u l=2u
X71 a_1508_13302# w_28620_25696# a_6838_13302# vdd pfet_03v3 ad=13p pd=50.52u as=13p ps=50.52u w=50u l=2u
X72 a_2135_25448# a_40438_43940# vss vss nfet_03v3 ad=0.61p pd=3.22u as=0.61p ps=3.22u w=1u l=0.5u
X73 a_21038_6704# a_21038_6704# vdd vdd pfet_03v3 ad=13p pd=50.52u as=32.5p ps=0.1013m w=50u l=4u
X74 out vbn vss vss nfet_03v3 ad=4.16p pd=16.52u as=4.16p ps=16.52u w=16u l=4u
X75 a_1438_1244# w_5020_25696# a_1508_13302# vdd pfet_03v3 ad=13p pd=50.52u as=13p ps=50.52u w=50u l=2u
X76 a_28022_1954# a_37038_1140# vdd vdd pfet_03v3 ad=0.65p pd=3.3u as=0.65p ps=3.3u w=1u l=20u
X77 a_1438_1244# a_1438_1244# vss vss nfet_03v3 ad=30.5p pd=0.10122m as=30.5p ps=0.10122m w=50u l=16u
X78 a_1508_13302# w_5020_25696# a_1438_1244# vdd pfet_03v3 ad=32.5p pd=0.1013m as=13p ps=50.52u w=50u l=2u
X79 vss vbn a_21038_6704# vss nfet_03v3 ad=4.16p pd=16.52u as=4.16p ps=16.52u w=16u l=4u
X80 vdd rst_amp a_2255_26003# vdd pfet_05v0 ad=0.38705p pd=2.08u as=0.1469p ps=1.085u w=0.565u l=0.5u
X81 a_1508_13302# w_28620_25696# a_6838_13302# vdd pfet_03v3 ad=13p pd=50.52u as=13p ps=50.52u w=50u l=2u
X82 vss rst_amp a_2067_26003# vss nfet_05v0 ad=0.2288p pd=1.58u as=93.59999f ps=0.88u w=0.36u l=0.6u
X83 vss vbn out vss nfet_03v3 ad=4.16p pd=16.52u as=4.16p ps=16.52u w=16u l=4u
X84 a_21038_6704# vbn vss vss nfet_03v3 ad=4.16p pd=16.52u as=4.16p ps=16.52u w=16u l=4u
X85 vss vbn a_21038_6704# vss nfet_03v3 ad=4.16p pd=16.52u as=4.16p ps=16.52u w=16u l=4u
X86 a_37038_1140# vcmo a_36238_23200# vss nfet_03v3 ad=0.305p pd=2.22u as=0.305p ps=2.22u w=0.5u l=40u
X87 a_14738_25200# a_2731_25872# vrs vss nfet_03v3 ad=0.305p pd=2.22u as=0.305p ps=2.22u w=0.5u l=0.5u
X88 a_21038_6704# vbn vss vss nfet_03v3 ad=4.16p pd=16.52u as=9.76p ps=33.22u w=16u l=4u
X89 w_6420_25696# a_21038_6704# vdd vdd pfet_03v3 ad=13p pd=50.52u as=13p ps=50.52u w=50u l=4u
X90 a_21038_6704# vbn vss vss nfet_03v3 ad=4.16p pd=16.52u as=4.16p ps=16.52u w=16u l=4u
X91 a_28938_25800# a_5238_25664# vcm vcm pfet_03v3 ad=0.2166p pd=2.06u as=0.2166p ps=2.06u w=0.22u l=0.5u
X92 a_40138_40000# a_14738_25200# out out pfet_03v3 ad=0.2166p pd=2.06u as=0.2166p ps=2.06u w=0.22u l=0.5u
X93 a_28022_1954# w_39820_39896# a_36238_23200# vss nfet_03v3 ad=0.305p pd=2.22u as=0.305p ps=2.22u w=0.5u l=40u
X94 a_28022_1954# vss cap_mim_2f0_m4m5_noshield c_width=31.465u c_length=31.465u
X95 a_1508_13302# w_5020_25696# a_1438_1244# vdd pfet_03v3 ad=13p pd=50.52u as=13p ps=50.52u w=50u l=2u
X96 a_40238_24600# vss cap_mim_2f0_m4m5_noshield c_width=44.595u c_length=44.595u
X97 a_1438_1244# w_5020_25696# a_1508_13302# vdd pfet_03v3 ad=13p pd=50.52u as=13p ps=50.52u w=50u l=2u
X98 a_40438_43940# a_40238_24600# vdd vdd pfet_03v3 ad=0.65p pd=3.3u as=0.65p ps=3.3u w=1u l=0.5u
X99 a_1438_1244# a_1438_1244# vss vss nfet_03v3 ad=30.5p pd=0.10122m as=30.5p ps=0.10122m w=50u l=16u
X100 out vbn vss vss nfet_03v3 ad=4.16p pd=16.52u as=4.16p ps=16.52u w=16u l=4u
X101 a_40316_41200# a_40238_24600# vss vss nfet_03v3 ad=0.61p pd=3.22u as=0.61p ps=3.22u w=1u l=0.5u
X102 a_28938_25800# a_5238_25664# w_28620_25696# w_28620_25696# pfet_03v3 ad=0.2166p pd=2.06u as=0.2166p ps=2.06u w=0.22u l=0.5u
X103 a_6838_13302# w_28620_25696# a_1508_13302# vdd pfet_03v3 ad=13p pd=50.52u as=13p ps=50.52u w=50u l=2u
X104 vdd a_21038_6704# a_1508_13302# vdd pfet_03v3 ad=13p pd=50.52u as=13p ps=50.52u w=50u l=4u
X105 w_28620_25696# vcm cap_mim_2f0_m4m5_noshield c_width=8.45u c_length=8.45u
X106 a_37038_1140# vcmo a_36238_23200# vss nfet_03v3 ad=0.305p pd=2.22u as=0.305p ps=2.22u w=0.5u l=40u
X107 a_5338_25800# a_5238_25664# w_6420_25696# w_6420_25696# pfet_03v3 ad=0.2166p pd=2.06u as=0.2166p ps=2.06u w=0.22u l=0.5u
X108 a_6838_13302# w_6420_25696# cap_mim_2f0_m4m5_noshield c_width=22u c_length=22u
X109 a_2731_25872# a_2067_26003# vss vss nfet_05v0 ad=0.3608p pd=2.52u as=0.2288p ps=1.58u w=0.82u l=0.6u
X110 a_6838_13302# w_28620_25696# a_1508_13302# vdd pfet_03v3 ad=13p pd=50.52u as=13p ps=50.52u w=50u l=2u
X111 a_21038_6704# vbn vss vss nfet_03v3 ad=4.16p pd=16.52u as=4.16p ps=16.52u w=16u l=4u
X112 w_5020_25696# w_6420_25696# cap_mim_2f0_m4m5_noshield c_width=8.45u c_length=8.45u
X113 a_37038_1140# a_37038_1140# vdd vdd pfet_03v3 ad=0.65p pd=3.3u as=0.65p ps=3.3u w=1u l=20u
X114 rec sw_rec vcm vdd pfet_03v3 ad=1.3p pd=5.3u as=1.3p ps=5.3u w=2u l=0.5u
X115 vss vbn out vss nfet_03v3 ad=9.76p pd=33.22u as=4.16p ps=16.52u w=16u l=4u
X116 vss vbn a_21038_6704# vss nfet_03v3 ad=4.16p pd=16.52u as=4.16p ps=16.52u w=16u l=4u
X117 a_1438_1244# w_5020_25696# a_1508_13302# vdd pfet_03v3 ad=13p pd=50.52u as=13p ps=50.52u w=50u l=2u
X118 a_1508_13302# w_5020_25696# a_1438_1244# vdd pfet_03v3 ad=13p pd=50.52u as=13p ps=50.52u w=50u l=2u
X119 a_40438_43940# sw_rec vdd vdd pfet_03v3 ad=0.65p pd=3.3u as=0.65p ps=3.3u w=1u l=0.5u
X120 a_14738_25200# a_2731_25872# vg2 vdd pfet_03v3 ad=0.325p pd=2.3u as=0.325p ps=2.3u w=0.5u l=0.5u
C0 a_2135_25448# a_5238_25664# 0.47896f
C1 w_5020_25696# sw_rec 0.54041f
C2 a_40238_24600# a_40438_43940# 0.84108f
C3 rst_amp ref 0.2679f
C4 w_39820_39896# a_28022_1954# 0.87958f
C5 a_20356_13242# vdd 16.58f
C6 a_5238_25664# vg2 0.11179f
C7 a_2135_25448# a_37038_1140# 4.22504f
C8 a_5338_25800# w_6420_25696# 0.26399f
C9 a_6838_13302# w_28620_25696# 30.7374f
C10 ref w_6420_25696# 0.17055f
C11 w_28620_25696# vbn 1.75458f
C12 rec a_14738_25200# 0.19704f
C13 sw_rec a_40438_43940# 1.49185f
C14 vrs sw_rec 0.0561f
C15 vcm sw_rec 12.1873f
C16 a_40238_24600# vdd 3.85564f
C17 w_28620_25696# vcmo 1.14072f
C18 a_36238_23200# vdd 0.06301f
C19 a_5238_25664# vg1 0.18648f
C20 w_39820_39896# a_37038_1140# 0.40489f
C21 w_28620_25696# w_5020_25696# 13.482f
C22 a_6838_13302# a_21648_13242# 0.13509f
C23 rec sw_rec_b 0.758f
C24 a_2135_25448# a_28938_25800# 0.08427f
C25 a_1508_13302# a_6838_13302# 17.9382f
C26 w_28620_25696# a_21038_6704# 1.03219f
C27 a_2731_25872# w_28620_25696# 0.01747f
C28 a_1508_13302# vbn 0.51891f
C29 vdd sw_rec 4.3492f
C30 a_1508_13302# w_5020_25696# 26.8622f
C31 a_28022_1954# w_6420_25696# 0.31009f
C32 a_21648_13242# a_21038_6704# 0.78649f
C33 vrs w_28620_25696# 0.15289f
C34 vcm w_28620_25696# 2.83481f
C35 out a_28022_1954# 0.8443f
C36 a_40238_24600# a_36238_23200# 0.05344f
C37 a_14738_25200# a_2135_25448# 0.33875f
C38 a_1508_13302# a_21038_6704# 7.24699f
C39 a_5238_25664# w_6420_25696# 1.9487f
C40 a_14738_25200# a_40138_40000# 1.34893f
C41 ref vbn 1.20571f
C42 out a_5238_25664# 0.21632f
C43 a_14738_25200# vg2 0.33147f
C44 ref vcmo 1.10165f
C45 a_5338_25800# w_5020_25696# 0.15363f
C46 a_1508_13302# a_1048_13242# 1.43412f
C47 a_37038_1140# w_6420_25696# 0.6656f
C48 w_5020_25696# ref 0.2674f
C49 vdd w_28620_25696# 12.1424f
C50 a_40238_24600# sw_rec 8.18659f
C51 a_2135_25448# sw_rec_b 0.03276f
C52 a_36238_23200# sw_rec 0.22787f
C53 out a_37038_1140# 0.16622f
C54 a_14738_25200# w_39820_39896# 1.68498f
C55 a_5338_25800# a_2731_25872# 0.01461f
C56 sw_rec_b vg2 2.53107f
C57 vdd a_21648_13242# 17.8569f
C58 a_14738_25200# vg1 0.54827f
C59 a_20356_13242# w_28620_25696# 0.10197f
C60 a_28022_1954# a_6838_13302# 2.88768f
C61 a_1508_13302# vdd 24.1647f
C62 a_28022_1954# vbn 0.66131f
C63 vrs ref 0.44618f
C64 vcm ref 0.99928f
C65 a_20356_13242# a_21648_13242# 0.12734f
C66 a_28022_1954# vcmo 0.10405f
C67 sw_rec_b vg1 11.1429f
C68 a_6838_13302# a_5238_25664# 1.85264f
C69 out a_28938_25800# 0.10445f
C70 a_5238_25664# vbn 0.66584f
C71 a_20356_13242# a_1508_13302# 1.49577f
C72 a_6838_13302# a_37038_1140# 2.53109f
C73 a_28022_1954# a_21038_6704# 0.13951f
C74 a_5338_25800# vdd 0.02186f
C75 a_5238_25664# w_5020_25696# 0.64494f
C76 a_37038_1140# vbn 0.82337f
C77 vdd ref 0.18337f
C78 rec vg2 1.24104f
C79 a_14738_25200# w_6420_25696# 0.24036f
C80 w_28620_25696# sw_rec 1.78478f
C81 a_37038_1140# vcmo 0.86588f
C82 rst_amp sw_rec_b 7.91979f
C83 a_2731_25872# a_5238_25664# 1.484f
C84 out a_14738_25200# 0.35985f
C85 a_37038_1140# a_21038_6704# 0.19124f
C86 rec vg1 0.40127f
C87 vrs a_5238_25664# 0.43038f
C88 sw_rec_b w_6420_25696# 0.10091f
C89 a_5238_25664# vcm 1.07788f
C90 a_27748_13242# w_6420_25696# 0.0543f
C91 a_40238_24600# ref 1.55218f
C92 a_28022_1954# vdd 4.01534f
C93 out a_27748_13242# 0.06303f
C94 a_2135_25448# vg2 0.01059f
C95 rec rst_amp 0.02711f
C96 vdd a_5238_25664# 4.03994f
C97 w_39820_39896# a_2135_25448# 1.59513f
C98 a_21648_13242# w_28620_25696# 0.09999f
C99 ref sw_rec 0.75014f
C100 a_14738_25200# vbn 0.08542f
C101 w_39820_39896# a_40138_40000# 0.30448f
C102 vdd a_37038_1140# 14.793f
C103 a_14738_25200# vcmo 2.79943f
C104 a_1508_13302# w_28620_25696# 28.5872f
C105 vcm a_28938_25800# 0.18507f
C106 a_28022_1954# a_40238_24600# 0.94823f
C107 a_28022_1954# a_36238_23200# 0.07759f
C108 vg1 vg2 2.86585f
C109 a_14738_25200# a_2731_25872# 1.93668f
C110 a_1508_13302# a_21648_13242# 0.16221f
C111 a_6838_13302# a_27748_13242# 0.14f
C112 sw_rec_b w_5020_25696# 1.25414f
C113 rst_amp a_2135_25448# 0.40535f
C114 w_28620_25696# ref 18.0705f
C115 a_14738_25200# vrs 0.03652f
C116 a_28022_1954# sw_rec 1.07821f
C117 a_14738_25200# vcm 1.57583f
C118 a_40238_24600# a_37038_1140# 0.06986f
C119 sw_rec_b a_2731_25872# 0.58036f
C120 a_36238_23200# a_37038_1140# 0.19288f
C121 rst_amp vg2 0.04896f
C122 a_2135_25448# w_6420_25696# 1.02129f
C123 a_5238_25664# sw_rec 1.81542f
C124 sw_rec_b vrs 0.27611f
C125 out a_2135_25448# 0.1509f
C126 rec vbn 0.25089f
C127 sw_rec_b vcm 0.5537f
C128 a_2135_25448# a_40316_41200# 0.01304f
C129 out a_40138_40000# 0.21253f
C130 sw_rec a_37038_1140# 0.17189f
C131 a_14738_25200# vdd 1.12665f
C132 rec vcmo 0.60241f
C133 rst_amp vg1 0.66689f
C134 rec w_5020_25696# 9.29475f
C135 w_39820_39896# w_6420_25696# 2.48536f
C136 out w_39820_39896# 2.49467f
C137 rec a_2731_25872# 0.10626f
C138 sw_rec_b vdd 0.04335f
C139 vg1 w_6420_25696# 0.11812f
C140 a_5238_25664# w_28620_25696# 0.819f
C141 vdd a_27748_13242# 18.193f
C142 rec vrs 0.12532f
C143 rec vcm 1.22825f
C144 a_28938_25800# sw_rec 0.01103f
C145 a_2135_25448# a_6838_13302# 0.21063f
C146 a_14738_25200# a_40238_24600# 0.13773f
C147 a_2135_25448# vbn 1.46065f
C148 a_2135_25448# vcmo 0.37737f
C149 a_2135_25448# w_5020_25696# 0.98427f
C150 vg2 vbn 0.05837f
C151 rec vdd 0.79562f
C152 a_14738_25200# sw_rec 0.36079f
C153 vg2 vcmo 0.07295f
C154 a_1438_1244# w_6420_25696# 0.97868f
C155 a_28022_1954# ref 1.09517f
C156 a_2135_25448# a_2731_25872# 0.44404f
C157 w_5020_25696# vg2 1.21046f
C158 out w_6420_25696# 0.50689f
C159 a_2135_25448# a_2067_26003# 0.60941f
C160 a_28938_25800# w_28620_25696# 0.12806f
C161 w_39820_39896# vcmo 3.07173f
C162 a_5338_25800# a_5238_25664# 1.30448f
C163 vg1 vbn 0.05125f
C164 a_2731_25872# vg2 0.63305f
C165 a_2135_25448# a_40438_43940# 2.07563f
C166 a_2135_25448# vrs 0.63632f
C167 a_2135_25448# vcm 2.41786f
C168 vg1 vcmo 0.03924f
C169 vg1 w_5020_25696# 0.59964f
C170 vrs vg2 9.80222f
C171 vcm vg2 0.37739f
C172 a_14738_25200# w_28620_25696# 0.65192f
C173 a_2731_25872# vg1 2.07909f
C174 w_39820_39896# vcm 0.01636f
C175 a_2135_25448# vdd 3.80654f
C176 a_1438_1244# a_6838_13302# 5.65882f
C177 rst_amp w_5020_25696# 0.06405f
C178 vrs vg1 9.69777f
C179 a_1438_1244# vbn 0.47766f
C180 a_6838_13302# w_6420_25696# 20.2073f
C181 vg1 vcm 0.63278f
C182 sw_rec_b w_28620_25696# 0.03346f
C183 w_6420_25696# vbn 4.32666f
C184 vdd vg2 0.99531f
C185 rec sw_rec 0.95545f
C186 out a_6838_13302# 0.6562f
C187 rst_amp a_2731_25872# 0.13932f
C188 out vbn 5.24482f
C189 w_6420_25696# vcmo 0.82198f
C190 a_1438_1244# w_5020_25696# 32.1625f
C191 a_28022_1954# a_37038_1140# 1.50999f
C192 w_5020_25696# w_6420_25696# 1.8965f
C193 a_1438_1244# a_856_1244# 0.16385f
C194 w_39820_39896# vdd 0.20594f
C195 rst_amp a_2067_26003# 0.52526f
C196 out vcmo 0.22166f
C197 rst_amp vrs 0.10611f
C198 w_6420_25696# a_21038_6704# 4.98862f
C199 a_2731_25872# w_6420_25696# 1.99509f
C200 vdd vg1 0.60245f
C201 a_2135_25448# a_40238_24600# 0.30316f
C202 a_2135_25448# a_36238_23200# 1.34268f
C203 out a_21038_6704# 0.09438f
C204 a_14738_25200# ref 0.67791f
C205 a_1438_1244# a_1048_13242# 0.02381f
C206 a_1438_1244# vrs 0.04403f
C207 rec w_28620_25696# 2.34887f
C208 vrs w_6420_25696# 1.29371f
C209 vcm w_6420_25696# 0.02643f
C210 out vcm 0.16751f
C211 a_40316_41200# a_40438_43940# 0.73451f
C212 rst_amp vdd 0.48739f
C213 a_2135_25448# sw_rec 1.32373f
C214 w_39820_39896# a_40238_24600# 0.50239f
C215 a_6838_13302# vbn 0.61236f
C216 w_39820_39896# a_36238_23200# 0.29745f
C217 sw_rec_b ref 0.48336f
C218 a_18020_1244# a_1438_1244# 1.4894f
C219 a_5238_25664# a_28938_25800# 1.2235f
C220 vg2 sw_rec 0.06961f
C221 a_6838_13302# w_5020_25696# 2.18694f
C222 vbn vcmo 9.88389f
C223 a_1438_1244# vdd 2.45414f
C224 vdd w_6420_25696# 5.07508f
C225 w_5020_25696# vbn 1.45967f
C226 a_14738_25200# a_28022_1954# 0.32575f
C227 out vdd 7.81312f
C228 w_39820_39896# sw_rec 0.57947f
C229 w_5020_25696# vcmo 0.49245f
C230 a_6838_13302# a_21038_6704# 1.98056f
C231 a_2731_25872# a_6838_13302# 0.28426f
C232 vbn a_21038_6704# 19.5036f
C233 a_20356_13242# a_1438_1244# 0.02475f
C234 a_20356_13242# w_6420_25696# 0.01464f
C235 vg1 sw_rec 0.25854f
C236 a_14738_25200# a_5238_25664# 0.27493f
C237 a_2135_25448# w_28620_25696# 0.27642f
C238 a_2731_25872# w_5020_25696# 0.55829f
C239 vrs a_6838_13302# 0.02077f
C240 rec ref 7.03078f
C241 vrs vbn 0.20544f
C242 vcm vbn 21.5203f
C243 w_28620_25696# vg2 0.89349f
C244 vrs vcmo 0.24327f
C245 w_5020_25696# a_1048_13242# 0.15962f
C246 vcm vcmo 0.13979f
C247 sw_rec_b a_5238_25664# 0.07931f
C248 vrs w_5020_25696# 0.66953f
C249 a_36238_23200# w_6420_25696# 0.09973f
C250 a_2731_25872# a_2067_26003# 0.18768f
C251 out a_40238_24600# 5.14105f
C252 out a_36238_23200# 0.21309f
C253 a_40238_24600# a_40316_41200# 0.54084f
C254 a_18020_1244# vbn 0.04867f
C255 a_2731_25872# vrs 2.42169f
C256 a_6838_13302# vdd 5.20894f
C257 vcm a_21038_6704# 0.01125f
C258 a_2731_25872# vcm 0.28442f
C259 vg1 w_28620_25696# 0.09994f
C260 vdd vbn 3.77627f
C261 sw_rec w_6420_25696# 0.15841f
C262 vdd vcmo 0.43726f
C263 vrs a_1048_13242# 0.01283f
C264 vdd w_5020_25696# 13.0615f
C265 out sw_rec 0.5519f
C266 a_20356_13242# a_6838_13302# 0.13494f
C267 vrs vcm 0.04692f
C268 a_40316_41200# sw_rec 0.613f
C269 a_5338_25800# a_2135_25448# 0.08427f
C270 a_20356_13242# vbn 0.29768f
C271 vdd a_21038_6704# 25.0421f
C272 a_2731_25872# vdd 2.30201f
C273 rec a_5238_25664# 0.66865f
C274 rst_amp w_28620_25696# 0.02088f
C275 vdd a_2067_26003# 0.49514f
C276 ref vg2 0.95693f
C277 vdd a_1048_13242# 16.7143f
C278 a_40238_24600# vbn 0.07347f
C279 vdd a_40438_43940# 2.77307f
C280 vrs vdd 1.0416f
C281 a_1438_1244# w_28620_25696# 0.72194f
C282 a_36238_23200# vbn 0.17015f
C283 vdd vcm 2.56424f
C284 w_39820_39896# ref 0.92549f
C285 w_28620_25696# w_6420_25696# 0.3033f
C286 a_40238_24600# vcmo 0.58758f
C287 a_36238_23200# vcmo 1.55515f
C288 out w_28620_25696# 0.06552f
C289 vg1 ref 0.45416f
C290 a_2135_25448# a_28022_1954# 3.06737f
C291 a_14738_25200# sw_rec_b 0.14262f
C292 sw_rec vbn 0.68629f
C293 a_1508_13302# a_1438_1244# 17.7598f
C294 sw_rec vcmo 0.18288f
C295 a_1508_13302# w_6420_25696# 0.50953f
C296 ref vss 21.9796f
C297 vbn vss 89.51479f
C298 vg2 vss 8.24837f
C299 vg1 vss 4.47473f
C300 rec vss 13.8788f
C301 vrs vss 4.5746f
C302 sw_rec_b vss 5.12864f
C303 rst_amp vss 5.11751f
C304 vcmo vss 38.5296f
C305 sw_rec vss 22.5736f
C306 vcm vss 9.25471f
C307 out vss 23.0858f
C308 vdd vss 1.1842p
C309 a_18020_1244# vss 17.3142f $ **FLOATING
C310 a_856_1244# vss 18.4824f $ **FLOATING
C311 a_27748_13242# vss 0.34755f $ **FLOATING
C312 a_21648_13242# vss 0.11865f $ **FLOATING
C313 a_20356_13242# vss 0.10663f $ **FLOATING
C314 a_6838_13302# vss 48.708f
C315 a_1438_1244# vss 37.5471f
C316 a_1508_13302# vss 2.91235f
C317 a_21038_6704# vss 12.2909f
C318 a_1048_13242# vss 0.31945f $ **FLOATING
C319 a_28938_25800# vss 0.72293f
C320 a_5338_25800# vss 0.69874f
C321 a_5238_25664# vss 7.46604f
C322 a_2731_25872# vss 3.8804f
C323 a_2067_26003# vss 0.48709f
C324 a_36238_23200# vss 4.39515f
C325 a_28022_1954# vss 32.366f
C326 a_37038_1140# vss 7.82209f
C327 a_40138_40000# vss 0.81996f
C328 a_14738_25200# vss 10.1121f
C329 a_40316_41200# vss 1.02949f
C330 a_40238_24600# vss 26.6349f
C331 a_2135_25448# vss 12.4985f
C332 a_40438_43940# vss 2.61482f
C333 w_28620_25696# vss 72.18561f
C334 w_6420_25696# vss 21.8461f
C335 w_5020_25696# vss 68.5484f
C336 w_39820_39896# vss 44.9128f
.ends
