** sch_path: /foss/designs/ENGN2912E_Project/AFE/amp/xschem/bias_gen.sch
.subckt bias_gen vbn vcm_in vg1 vcm_out vg2 vdd vss
*.PININFO vbn:O vcm_in:O vg1:O vcm_out:O vg2:O vdd:B vss:B
Xmp2 a a vdd vdd pfet_03v3 L='4u' W='40u' nf=1 ad='DIFF*40u*0.18u' as='DIFF*40u*0.18u' pd='DIFF*2*(40u+0.18u)' ps='DIFF*2*(40u+0.18u)'
+ nrd=0 nrs=0 sa=0 sb=0 sd=0 m='1'
Xmp1 vbn a vdd vdd pfet_03v3 L='4u' W='40u' nf=1 ad='DIFF*40u*0.18u' as='DIFF*40u*0.18u' pd='DIFF*2*(40u+0.18u)' ps='DIFF*2*(40u+0.18u)'
+ nrd=0 nrs=0 sa=0 sb=0 sd=0 m='1'
Xmn1 vbn vbn vss vss nfet_03v3 L='4u' W='16u' nf=1 ad='DIFF*16u*0.18u' as='DIFF*16u*0.18u' pd='DIFF*2*(16u+0.18u)' ps='DIFF*2*(16u+0.18u)'
+ nrd=0 nrs=0 sa=0 sb=0 sd=0 m='1'
Xmn2 a vbn r1 vss nfet_03v3 L='4u' W='16u' nf=1 ad='DIFF*16u*0.18u' as='DIFF*16u*0.18u' pd='DIFF*2*(16u+0.18u)' ps='DIFF*2*(16u+0.18u)'
+ nrd=0 nrs=0 sa=0 sb=0 sd=0 m='4'
Xrb vss r1 vss ppolyf_u_1k r_width='2u' r_length='RB_L'
Xs1 s1 s1 vdd vdd pfet_03v3 L='4u' W='0.5u' nf=1 ad='DIFF*0.5u*0.18u' as='DIFF*0.5u*0.18u' pd='DIFF*2*(0.5u+0.18u)' ps='DIFF*2*(0.5u+0.18u)'
+ nrd=0 nrs=0 sa=0 sb=0 sd=0 m='1'
Xs2 s2 s2 s1 vdd pfet_03v3 L='4u' W='0.5u' nf=1 ad='DIFF*0.5u*0.18u' as='DIFF*0.5u*0.18u' pd='DIFF*2*(0.5u+0.18u)' ps='DIFF*2*(0.5u+0.18u)'
+ nrd=0 nrs=0 sa=0 sb=0 sd=0 m='1'
Xs3 vbn vbn s2 vdd pfet_03v3 L='4u' W='0.5u' nf=1 ad='DIFF*0.5u*0.18u' as='DIFF*0.5u*0.18u' pd='DIFF*2*(0.5u+0.18u)' ps='DIFF*2*(0.5u+0.18u)'
+ nrd=0 nrs=0 sa=0 sb=0 sd=0 m='1'
Xra1 vg1 vdd vss ppolyf_u_1k r_width='1u' r_length='(VDDN-VCM_IN-VTT)/ILAD/1000*1u'
Xra2 vcm_in vg1 vss ppolyf_u_1k r_width='1u' r_length='VTT/ILAD/1000*1u'
Xra3 vss vcm_in vss ppolyf_u_1k r_width='1u' r_length='VCM_IN/ILAD/1000*1u'
Xrb1 vg2 vdd vss ppolyf_u_1k r_width='1u' r_length='(VDDN-VOCM-VTT2)/ILAD/1000*1u'
Xrb2 vcm_out vg2 vss ppolyf_u_1k r_width='1u' r_length='VTT2/ILAD/1000*1u'
Xrb3 vss vcm_out vss ppolyf_u_1k r_width='1u' r_length='VOCM/ILAD/1000*1u'
.ends
