** sch_path: /foss/designs/ENGN2912E_Project/AFE/amp/xschem/ota1.sch
.subckt ota1 inp inn ibias out vdd vss
*.PININFO inp:I inn:I out:O vdd:B vss:B ibias:I
Xmb ibias ibias vdd vdd pfet_03v3 L='OTA_LT' W='OTA_WT' nf=1 ad='DIFF*OTA_WT*0.18u' as='DIFF*OTA_WT*0.18u' pd='DIFF*2*(OTA_WT+0.18u)'
+ ps='DIFF*2*(OTA_WT+0.18u)' nrd=0 nrs=0 sa=0 sb=0 sd=0 m='OTA_KB'
Xmt tail ibias vdd vdd pfet_03v3 L='OTA_LT' W='OTA_WT' nf=1 ad='DIFF*OTA_WT*0.18u' as='DIFF*OTA_WT*0.18u' pd='DIFF*2*(OTA_WT+0.18u)'
+ ps='DIFF*2*(OTA_WT+0.18u)' nrd=0 nrs=0 sa=0 sb=0 sd=0 m='OTA_KT'
Xm1 d1 inn tail vdd pfet_03v3 L='OTA_LP' W='OTA_WP' nf=1 ad='DIFF*OTA_WP*0.18u' as='DIFF*OTA_WP*0.18u' pd='DIFF*2*(OTA_WP+0.18u)' ps='DIFF*2*(OTA_WP+0.18u)'
+ nrd=0 nrs=0 sa=0 sb=0 sd=0 m='OTA_KP'
Xm2 o1 inp tail vdd pfet_03v3 L='OTA_LP' W='OTA_WP' nf=1 ad='DIFF*OTA_WP*0.18u' as='DIFF*OTA_WP*0.18u' pd='DIFF*2*(OTA_WP+0.18u)' ps='DIFF*2*(OTA_WP+0.18u)'
+ nrd=0 nrs=0 sa=0 sb=0 sd=0 m='OTA_KP'
Xm3 d1 d1 vss vss nfet_03v3 L='OTA_LN' W='OTA_WN' nf=1 ad='DIFF*OTA_WN*0.18u' as='DIFF*OTA_WN*0.18u' pd='DIFF*2*(OTA_WN+0.18u)' ps='DIFF*2*(OTA_WN+0.18u)'
+ nrd=0 nrs=0 sa=0 sb=0 sd=0 m='OTA_KN'
Xm4 o1 d1 vss vss nfet_03v3 L='OTA_LN' W='OTA_WN' nf=1 ad='DIFF*OTA_WN*0.18u' as='DIFF*OTA_WN*0.18u' pd='DIFF*2*(OTA_WN+0.18u)' ps='DIFF*2*(OTA_WN+0.18u)'
+ nrd=0 nrs=0 sa=0 sb=0 sd=0 m='OTA_KN'
Xm7 out ibias vdd vdd pfet_03v3 L='OTA_LT' W='OTA_WT' nf=1 ad='DIFF*OTA_WT*0.18u' as='DIFF*OTA_WT*0.18u' pd='DIFF*2*(OTA_WT+0.18u)'
+ ps='DIFF*2*(OTA_WT+0.18u)' nrd=0 nrs=0 sa=0 sb=0 sd=0 m='OTA_K7'
Xm6 out o1 vss vss nfet_03v3 L='OTA_LN' W='OTA_WN' nf=1 ad='DIFF*OTA_WN*0.18u' as='DIFF*OTA_WN*0.18u' pd='DIFF*2*(OTA_WN+0.18u)' ps='DIFF*2*(OTA_WN+0.18u)'
+ nrd=0 nrs=0 sa=0 sb=0 sd=0 m='OTA_K6'
Xcc o1 out cap_mim_2f0_m2m3_noshield c_width='OTA_LCC' c_length='OTA_LCC'
.ends
