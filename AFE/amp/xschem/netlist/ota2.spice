** sch_path: /foss/designs/ENGN2912E_Project/AFE/amp/xschem/ota2.sch
.subckt ota2 inp inn vbn out vdd vss
*.PININFO inp:I inn:I vbn:I out:O vdd:B vss:B
Xmt tail vbn vss vss nfet_03v3 L='OTA2_LT' W='OTA2_WT' nf=1 ad='DIFF*OTA2_WT*0.18u' as='DIFF*OTA2_WT*0.18u' pd='DIFF*2*(OTA2_WT+0.18u)'
+ ps='DIFF*2*(OTA2_WT+0.18u)' nrd=0 nrs=0 sa=0 sb=0 sd=0 m='1'
Xm1 d1 inp tail vss nfet_03v3 L='OTA2_LP' W='OTA2_WP' nf=1 ad='DIFF*OTA2_WP*0.18u' as='DIFF*OTA2_WP*0.18u' pd='DIFF*2*(OTA2_WP+0.18u)'
+ ps='DIFF*2*(OTA2_WP+0.18u)' nrd=0 nrs=0 sa=0 sb=0 sd=0 m='1'
Xm2 o2 inn tail vss nfet_03v3 L='OTA2_LP' W='OTA2_WP' nf=1 ad='DIFF*OTA2_WP*0.18u' as='DIFF*OTA2_WP*0.18u' pd='DIFF*2*(OTA2_WP+0.18u)'
+ ps='DIFF*2*(OTA2_WP+0.18u)' nrd=0 nrs=0 sa=0 sb=0 sd=0 m='1'
Xm3 d1 d1 vdd vdd pfet_03v3 L='OTA2_LL' W='OTA2_WL' nf=1 ad='DIFF*OTA2_WL*0.18u' as='DIFF*OTA2_WL*0.18u' pd='DIFF*2*(OTA2_WL+0.18u)'
+ ps='DIFF*2*(OTA2_WL+0.18u)' nrd=0 nrs=0 sa=0 sb=0 sd=0 m='1'
Xm4 o2 d1 vdd vdd pfet_03v3 L='OTA2_LL' W='OTA2_WL' nf=1 ad='DIFF*OTA2_WL*0.18u' as='DIFF*OTA2_WL*0.18u' pd='DIFF*2*(OTA2_WL+0.18u)'
+ ps='DIFF*2*(OTA2_WL+0.18u)' nrd=0 nrs=0 sa=0 sb=0 sd=0 m='1'
Xmf vdd o2 out vss nfet_06v0_nvt L='OTA2_LF' W='OTA2_WF' nf=1 ad='DIFF*OTA2_WF*0.18u' as='DIFF*OTA2_WF*0.18u' pd='DIFF*2*(OTA2_WF+0.18u)'
+ ps='DIFF*2*(OTA2_WF+0.18u)' nrd=0 nrs=0 sa=0 sb=0 sd=0 m='1'
Xms out vbn vss vss nfet_03v3 L='4u' W='16u' nf=1 ad='DIFF*16u*0.18u' as='DIFF*16u*0.18u' pd='DIFF*2*(16u+0.18u)' ps='DIFF*2*(16u+0.18u)'
+ nrd=0 nrs=0 sa=0 sb=0 sd=0 m='BM_KSF'
Xcc o2 vss cap_mim_2f0_m2m3_noshield c_width='LCC2' c_length='LCC2'
.ends
