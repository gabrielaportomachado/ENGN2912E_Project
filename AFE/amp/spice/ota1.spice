* A3 stage-1 OTA: two-stage Miller, PMOS input pair, NMOS mirror load, NMOS common-source 2nd stage.
* Instance parameters nf/ad/as/pd/ps/nrd/nrs/sa/sb/sd are the ones the PDK xschem symbols pass, set EXPLICITLY to 0 (nf=1): junction areas/
* perimeters and diffusion resistances are NOT modelled (A3 limitation).  Nonzero ad/as/pd/ps make the ngspice transient fail
* ('timestep too small' at ~1 us, UNEXPLAINED), so the xschem symbols are overridden with 0 as well.  Requires spice/ota1_params.spice and a model file included first.
* Pin order = the order xschem emits (inputs, outputs, inouts): inp inn ibias out vdd vss.
* Pins: inn = gate of M1 (diode side; INVERTING input, since stage 2 inverts), inp = gate of M2 (NON-inverting).
*       ibias = input of the PMOS bias diode: the testbench sinks IBIAS from it to ground (IDEAL in A3; real bias in A4).
.subckt ota1 inp inn ibias out vdd vss
* bias diode and tail (PMOS)
Xmb ibias ibias vdd vdd pfet_03v3 L={OTA_LT} W={OTA_WT} nf=1 ad=0 as=0 pd=0 ps=0 nrd=0 nrs=0 sa=0 sb=0 sd=0 m={OTA_KB}
Xmt tail ibias vdd vdd pfet_03v3 L={OTA_LT} W={OTA_WT} nf=1 ad=0 as=0 pd=0 ps=0 nrd=0 nrs=0 sa=0 sb=0 sd=0 m={OTA_KT}
* input pair
Xm1 d1 inn tail vdd pfet_03v3 L={OTA_LP} W={OTA_WP} nf=1 ad=0 as=0 pd=0 ps=0 nrd=0 nrs=0 sa=0 sb=0 sd=0 m={OTA_KP}
Xm2 o1 inp tail vdd pfet_03v3 L={OTA_LP} W={OTA_WP} nf=1 ad=0 as=0 pd=0 ps=0 nrd=0 nrs=0 sa=0 sb=0 sd=0 m={OTA_KP}
* NMOS mirror load (M3 diode, M4 output side)
Xm3 d1 d1 vss vss nfet_03v3 L={OTA_LN} W={OTA_WN} nf=1 ad=0 as=0 pd=0 ps=0 nrd=0 nrs=0 sa=0 sb=0 sd=0 m={OTA_KN}
Xm4 o1 d1 vss vss nfet_03v3 L={OTA_LN} W={OTA_WN} nf=1 ad=0 as=0 pd=0 ps=0 nrd=0 nrs=0 sa=0 sb=0 sd=0 m={OTA_KN}
* second stage: NMOS common source + PMOS current source (mirror of the bias diode)
Xm6 out o1 vss vss nfet_03v3 L={OTA_LN} W={OTA_WN} nf=1 ad=0 as=0 pd=0 ps=0 nrd=0 nrs=0 sa=0 sb=0 sd=0 m={OTA_K6}
Xm7 out ibias vdd vdd pfet_03v3 L={OTA_LT} W={OTA_WT} nf=1 ad=0 as=0 pd=0 ps=0 nrd=0 nrs=0 sa=0 sb=0 sd=0 m={OTA_K7}
* Miller compensation, o1 -> out
Xcc o1 out cap_mim_2f0_m2m3_noshield c_length={OTA_LCC} c_width={OTA_LCC}
.ends ota1
