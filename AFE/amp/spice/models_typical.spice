* typical-corner models (A2): MOS corner + MIM corner (mimcap_typical).
.include /foss/pdks/gf180mcuD/libs.tech/ngspice/design.ngspice
.lib /foss/pdks/gf180mcuD/libs.tech/ngspice/sm141064.ngspice typical
.lib /foss/pdks/gf180mcuD/libs.tech/ngspice/sm141064.ngspice mimcap_typical
* A4a: poly-resistor corner for the bias and ladder resistors.  F1 (Decision 44a): they are ppolyf_u_1k now, rsh 1000 / 800 / 1200 Ohm/sq for typical / ff / ss
* (the ppolyf_u_3k of A4a-X2 had 3000 / 2250 / 3750 Ohm/sq; that device does not exist in gf180mcuD).
.lib /foss/pdks/gf180mcuD/libs.tech/ngspice/sm141064.ngspice res_typical
