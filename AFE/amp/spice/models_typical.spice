* typical-corner models (A2): MOS corner + MIM corner (mimcap_typical).
.include /foss/pdks/gf180mcuD/libs.tech/ngspice/design.ngspice
.lib /foss/pdks/gf180mcuD/libs.tech/ngspice/sm141064.ngspice typical
.lib /foss/pdks/gf180mcuD/libs.tech/ngspice/sm141064.ngspice mimcap_typical
* A4a: poly-resistor corner (rsh 3000 / 2250 / 3750 Ohm/sq for typical / ff / ss) for the bias and ladder resistors.
.lib /foss/pdks/gf180mcuD/libs.tech/ngspice/sm141064.ngspice res_typical
