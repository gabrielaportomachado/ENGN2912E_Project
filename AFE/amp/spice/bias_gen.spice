* A4a REAL bias (shared by all channels): self-biased beta-multiplier master (vbn) + two resistor ladders (VDD-ratiometric references).
* Needs a model file (with the res_<corner> section) and afe_params.spice first.  Candidate chosen by the user (rule 10): beta-multiplier + ladder taps.
* Master: Mn1 (16u/4u, diode, vbn), Mn2 (4 x 16u/4u, source resistor Rb), PMOS mirror Mp1/Mp2; I = 2(1-1/sqrt(4))^2/(beta Rb^2) ~ 0.85 uA at Rb = 60 kOhm (typ 27 C).
* Start-up: three diode-connected PMOS from vdd to vbn (conduct only while vbn is near 0).
* Outputs: vbn (NMOS mirror gate bias), vcm_in (stage-1 gate bias, 1.5 V), vg1 (stage-1 pseudo-R gate = vcm_in + VTT), vcm_out (VOUT_CM), vg2 (stage-2 pseudo-R gate = vcm_out + VTT).
* Ladders: ILAD = 2 uA each, 1 kOhm/sq high-resistance poly (ppolyf_u_1k, the ONLY HRES poly of gf180mcuD) width 1u, so L[um] = R/1000.  All taps scale with VDD (ratiometric).
* F1 / Decision 44a (2026-11-20): was ppolyf_u_3k with L = R/3000 (that device does not exist in the D variant: LVS cannot match).  Same resistance = 3x the squares at the same width:
* ladder A 1650 um, ladder B 1650 um of 1 um poly in total (RA1 725 / RA2 100 / RA3 825 um, RB1 375 / RB2 450 / RB3 825 um).  Check: AFE/review/sim/f1_bias_op.log.
* Pin order = the order xschem emits (outputs, then inouts).
.subckt bias_gen vbn vcm_in vg1 vcm_out vg2 vdd vss
Xmp2 a a vdd vdd pfet_03v3 W=40u L=4u nf=1 ad={DIFF*40u*0.18u} as={DIFF*40u*0.18u} pd={DIFF*2*(40u+0.18u)} ps={DIFF*2*(40u+0.18u)} nrd=0 nrs=0 sa=0 sb=0 sd=0
Xmp1 vbn a vdd vdd pfet_03v3 W=40u L=4u nf=1 ad={DIFF*40u*0.18u} as={DIFF*40u*0.18u} pd={DIFF*2*(40u+0.18u)} ps={DIFF*2*(40u+0.18u)} nrd=0 nrs=0 sa=0 sb=0 sd=0
Xmn1 vbn vbn vss vss nfet_03v3 W=16u L=4u nf=1 ad={DIFF*16u*0.18u} as={DIFF*16u*0.18u} pd={DIFF*2*(16u+0.18u)} ps={DIFF*2*(16u+0.18u)} nrd=0 nrs=0 sa=0 sb=0 sd=0
Xmn2 a vbn r1 vss nfet_03v3 W=16u L=4u nf=1 ad={DIFF*16u*0.18u} as={DIFF*16u*0.18u} pd={DIFF*2*(16u+0.18u)} ps={DIFF*2*(16u+0.18u)} nrd=0 nrs=0 sa=0 sb=0 sd=0 m=4
Xrb r1 vss vss ppolyf_u_1k r_length={RB_L} r_width=2u
Xs1 s1 s1 vdd vdd pfet_03v3 W=0.5u L=4u nf=1 ad={DIFF*0.5u*0.18u} as={DIFF*0.5u*0.18u} pd={DIFF*2*(0.5u+0.18u)} ps={DIFF*2*(0.5u+0.18u)} nrd=0 nrs=0 sa=0 sb=0 sd=0
Xs2 s2 s2 s1 vdd pfet_03v3 W=0.5u L=4u nf=1 ad={DIFF*0.5u*0.18u} as={DIFF*0.5u*0.18u} pd={DIFF*2*(0.5u+0.18u)} ps={DIFF*2*(0.5u+0.18u)} nrd=0 nrs=0 sa=0 sb=0 sd=0
Xs3 vbn vbn s2 vdd pfet_03v3 W=0.5u L=4u nf=1 ad={DIFF*0.5u*0.18u} as={DIFF*0.5u*0.18u} pd={DIFF*2*(0.5u+0.18u)} ps={DIFF*2*(0.5u+0.18u)} nrd=0 nrs=0 sa=0 sb=0 sd=0
* ladder A: vdd - RA1 - vg1 - RA2 - vcm_in - RA3 - vss
XrA1 vdd vg1 vss ppolyf_u_1k r_length={(VDDN-VCM_IN-VTT)/ILAD/1000*1u} r_width=1u
XrA2 vg1 vcm_in vss ppolyf_u_1k r_length={VTT/ILAD/1000*1u} r_width=1u
XrA3 vcm_in vss vss ppolyf_u_1k r_length={VCM_IN/ILAD/1000*1u} r_width=1u
* ladder B: vdd - RB1 - vg2 - RB2 - vcm_out - RB3 - vss
XrB1 vdd vg2 vss ppolyf_u_1k r_length={(VDDN-VOCM-VTT2)/ILAD/1000*1u} r_width=1u
XrB2 vg2 vcm_out vss ppolyf_u_1k r_length={VTT2/ILAD/1000*1u} r_width=1u
XrB3 vcm_out vss vss ppolyf_u_1k r_length={VOCM/ILAD/1000*1u} r_width=1u
.ends bias_gen
