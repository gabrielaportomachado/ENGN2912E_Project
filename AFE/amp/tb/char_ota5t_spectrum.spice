* A1: spectrum 0.1 Hz-10 kHz of the recommended 5T pair (pair 16x50u/2u, load 4x50u/8u). FN tag set by sed.
* so v(out) noise = input-referred noise of pair + tail + NMOS mirror load; tail/bias are
* noiseless-ish: tail noise is common-mode and mostly cancels; bias diode shares the mirror).
* Single case; scripts/run_ota5t_sweep.sh overrides the .param line and 'set' line.
.include ../spice/models_typical.spice
.param LLP=2u LLN=8u KP=16 KT=2 KN=4 FN=0
.param fnoicor=FN
Vdd vdd 0 3.3
Iref bn 0 20u
Xbias bn bn vdd vdd pfet_03v3 W=50u L=4u m={KT}
Xtail tail bn vdd vdd pfet_03v3 W=50u L=4u m={KT}
Xm1 d1 vin tail vdd pfet_03v3 W=50u L={LLP} m={KP}
Xm2 out vout tail vdd pfet_03v3 W=50u L={LLP} m={KP}
Xn1 d1 d1 0 0 nfet_03v3 W=50u L={LLN} m={KN}
Xn2 out d1 0 0 nfet_03v3 W=50u L={LLN} m={KN}
Vin vin 0 dc 1.2 ac 1
Eb vout 0 out 0 1
.control
noise v(out) Vin dec 40 0.1 10k
setplot noise1
wrdata ../sim/char_ota5t_spectrum_FNTAG.csv inoise_spectrum
quit
.endc
.end
