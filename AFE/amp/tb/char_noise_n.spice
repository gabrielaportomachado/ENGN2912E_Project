* A1: nfet_03v3 input-referred noise, typical, 27C. Single case; scripts/run_noise_sweep.sh
* overrides the .param line below (MM LL FN, and the 'set idt' line) and collects the RESULT line.
* Source/bulk 0 V, Vds = 0.6 V. Output = drain current through a 1-ohm CCVS, so
* inoise = id_noise/gm (referred to the gate). inoise_total is rms V (unit checked in
* char_noise_check_R.spice).
.include ../spice/models_typical.spice
.param MM=2 LL=1u FN=0   $ total W = MM*50u via m= (nf does not scale W in this model; bin max W is 100u)
.param fnoicor=FN
Vs s 0 0
Vin g 0 dc 0.7 ac 1
Vsd d 0 0.6
Xn d g s s nfet_03v3 W=50u m={MM} L={LL}
H1 out 0 Vsd -1
.control
set idt = 10u
save all @m.xn.m0[gm] @m.xn.m0[cgg] @m.xn.m0[id]
dc Vin 0.2 1.4 0.002
meas dc vgt find v(g) when i(Vsd)=-$idt cross=1
set vgs = $&vgt
let vgsv = vgt
set vgs2 = $&vgsv
alter Vin dc = $vgs
op
set gmv = $&@m.xn.m0[gm]
set cggv = $&@m.xn.m0[cgg]
noise v(out) Vin dec 50 0.5 300
set vn = $&inoise_total
echo RESULT $vgs2 $gmv $cggv $vn
wrdata ../sim/char_noise_p_spectrum_tmp.csv inoise_spectrum
quit
.endc
.end
