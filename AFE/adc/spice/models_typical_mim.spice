* D2: typical MOS + MIM corner (mimcap_typical).  sw_stat_* stay at the PDK defaults (0) unless a testbench overrides them AFTER this include.
.include /foss/pdks/gf180mcuD/libs.tech/ngspice/design.ngspice
.lib /foss/pdks/gf180mcuD/libs.tech/ngspice/sm141064.ngspice typical
.lib /foss/pdks/gf180mcuD/libs.tech/ngspice/sm141064.ngspice mimcap_typical
