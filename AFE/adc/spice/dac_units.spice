* D2 split-cap DAC: 6+6 split, units 5 x 5 um MIM (PDK cap_mim_2f0), bridge T-M, dummy unit on M (bottom pin bd).  Generated by scripts/gen_dac.py; widths solved so that C = nominal*(1+dev).
.subckt dac_units t m b0 b1 b2 b3 b4 b5 b6 b7 b8 b9 b10 b11 bd
Xc0_0 m b0 cap_mim_2f0_m2m3_noshield c_length=5u c_width=5.000000u
Xc1_1 m b1 cap_mim_2f0_m2m3_noshield c_length=5u c_width=5.000000u
Xc1_2 m b1 cap_mim_2f0_m2m3_noshield c_length=5u c_width=5.000000u
Xc2_3 m b2 cap_mim_2f0_m2m3_noshield c_length=5u c_width=5.000000u
Xc2_4 m b2 cap_mim_2f0_m2m3_noshield c_length=5u c_width=5.000000u
Xc2_5 m b2 cap_mim_2f0_m2m3_noshield c_length=5u c_width=5.000000u
Xc2_6 m b2 cap_mim_2f0_m2m3_noshield c_length=5u c_width=5.000000u
Xc3_7 m b3 cap_mim_2f0_m2m3_noshield c_length=5u c_width=5.000000u
Xc3_8 m b3 cap_mim_2f0_m2m3_noshield c_length=5u c_width=5.000000u
Xc3_9 m b3 cap_mim_2f0_m2m3_noshield c_length=5u c_width=5.000000u
Xc3_10 m b3 cap_mim_2f0_m2m3_noshield c_length=5u c_width=5.000000u
Xc3_11 m b3 cap_mim_2f0_m2m3_noshield c_length=5u c_width=5.000000u
Xc3_12 m b3 cap_mim_2f0_m2m3_noshield c_length=5u c_width=5.000000u
Xc3_13 m b3 cap_mim_2f0_m2m3_noshield c_length=5u c_width=5.000000u
Xc3_14 m b3 cap_mim_2f0_m2m3_noshield c_length=5u c_width=5.000000u
Xc4_15 m b4 cap_mim_2f0_m2m3_noshield c_length=5u c_width=5.000000u
Xc4_16 m b4 cap_mim_2f0_m2m3_noshield c_length=5u c_width=5.000000u
Xc4_17 m b4 cap_mim_2f0_m2m3_noshield c_length=5u c_width=5.000000u
Xc4_18 m b4 cap_mim_2f0_m2m3_noshield c_length=5u c_width=5.000000u
Xc4_19 m b4 cap_mim_2f0_m2m3_noshield c_length=5u c_width=5.000000u
Xc4_20 m b4 cap_mim_2f0_m2m3_noshield c_length=5u c_width=5.000000u
Xc4_21 m b4 cap_mim_2f0_m2m3_noshield c_length=5u c_width=5.000000u
Xc4_22 m b4 cap_mim_2f0_m2m3_noshield c_length=5u c_width=5.000000u
Xc4_23 m b4 cap_mim_2f0_m2m3_noshield c_length=5u c_width=5.000000u
Xc4_24 m b4 cap_mim_2f0_m2m3_noshield c_length=5u c_width=5.000000u
Xc4_25 m b4 cap_mim_2f0_m2m3_noshield c_length=5u c_width=5.000000u
Xc4_26 m b4 cap_mim_2f0_m2m3_noshield c_length=5u c_width=5.000000u
Xc4_27 m b4 cap_mim_2f0_m2m3_noshield c_length=5u c_width=5.000000u
Xc4_28 m b4 cap_mim_2f0_m2m3_noshield c_length=5u c_width=5.000000u
Xc4_29 m b4 cap_mim_2f0_m2m3_noshield c_length=5u c_width=5.000000u
Xc4_30 m b4 cap_mim_2f0_m2m3_noshield c_length=5u c_width=5.000000u
Xc5_31 m b5 cap_mim_2f0_m2m3_noshield c_length=5u c_width=5.000000u
Xc5_32 m b5 cap_mim_2f0_m2m3_noshield c_length=5u c_width=5.000000u
Xc5_33 m b5 cap_mim_2f0_m2m3_noshield c_length=5u c_width=5.000000u
Xc5_34 m b5 cap_mim_2f0_m2m3_noshield c_length=5u c_width=5.000000u
Xc5_35 m b5 cap_mim_2f0_m2m3_noshield c_length=5u c_width=5.000000u
Xc5_36 m b5 cap_mim_2f0_m2m3_noshield c_length=5u c_width=5.000000u
Xc5_37 m b5 cap_mim_2f0_m2m3_noshield c_length=5u c_width=5.000000u
Xc5_38 m b5 cap_mim_2f0_m2m3_noshield c_length=5u c_width=5.000000u
Xc5_39 m b5 cap_mim_2f0_m2m3_noshield c_length=5u c_width=5.000000u
Xc5_40 m b5 cap_mim_2f0_m2m3_noshield c_length=5u c_width=5.000000u
Xc5_41 m b5 cap_mim_2f0_m2m3_noshield c_length=5u c_width=5.000000u
Xc5_42 m b5 cap_mim_2f0_m2m3_noshield c_length=5u c_width=5.000000u
Xc5_43 m b5 cap_mim_2f0_m2m3_noshield c_length=5u c_width=5.000000u
Xc5_44 m b5 cap_mim_2f0_m2m3_noshield c_length=5u c_width=5.000000u
Xc5_45 m b5 cap_mim_2f0_m2m3_noshield c_length=5u c_width=5.000000u
Xc5_46 m b5 cap_mim_2f0_m2m3_noshield c_length=5u c_width=5.000000u
Xc5_47 m b5 cap_mim_2f0_m2m3_noshield c_length=5u c_width=5.000000u
Xc5_48 m b5 cap_mim_2f0_m2m3_noshield c_length=5u c_width=5.000000u
Xc5_49 m b5 cap_mim_2f0_m2m3_noshield c_length=5u c_width=5.000000u
Xc5_50 m b5 cap_mim_2f0_m2m3_noshield c_length=5u c_width=5.000000u
Xc5_51 m b5 cap_mim_2f0_m2m3_noshield c_length=5u c_width=5.000000u
Xc5_52 m b5 cap_mim_2f0_m2m3_noshield c_length=5u c_width=5.000000u
Xc5_53 m b5 cap_mim_2f0_m2m3_noshield c_length=5u c_width=5.000000u
Xc5_54 m b5 cap_mim_2f0_m2m3_noshield c_length=5u c_width=5.000000u
Xc5_55 m b5 cap_mim_2f0_m2m3_noshield c_length=5u c_width=5.000000u
Xc5_56 m b5 cap_mim_2f0_m2m3_noshield c_length=5u c_width=5.000000u
Xc5_57 m b5 cap_mim_2f0_m2m3_noshield c_length=5u c_width=5.000000u
Xc5_58 m b5 cap_mim_2f0_m2m3_noshield c_length=5u c_width=5.000000u
Xc5_59 m b5 cap_mim_2f0_m2m3_noshield c_length=5u c_width=5.000000u
Xc5_60 m b5 cap_mim_2f0_m2m3_noshield c_length=5u c_width=5.000000u
Xc5_61 m b5 cap_mim_2f0_m2m3_noshield c_length=5u c_width=5.000000u
Xc5_62 m b5 cap_mim_2f0_m2m3_noshield c_length=5u c_width=5.000000u
Xc6_64 t b6 cap_mim_2f0_m2m3_noshield c_length=5u c_width=5.000000u
Xc7_65 t b7 cap_mim_2f0_m2m3_noshield c_length=5u c_width=5.000000u
Xc7_66 t b7 cap_mim_2f0_m2m3_noshield c_length=5u c_width=5.000000u
Xc8_67 t b8 cap_mim_2f0_m2m3_noshield c_length=5u c_width=5.000000u
Xc8_68 t b8 cap_mim_2f0_m2m3_noshield c_length=5u c_width=5.000000u
Xc8_69 t b8 cap_mim_2f0_m2m3_noshield c_length=5u c_width=5.000000u
Xc8_70 t b8 cap_mim_2f0_m2m3_noshield c_length=5u c_width=5.000000u
Xc9_71 t b9 cap_mim_2f0_m2m3_noshield c_length=5u c_width=5.000000u
Xc9_72 t b9 cap_mim_2f0_m2m3_noshield c_length=5u c_width=5.000000u
Xc9_73 t b9 cap_mim_2f0_m2m3_noshield c_length=5u c_width=5.000000u
Xc9_74 t b9 cap_mim_2f0_m2m3_noshield c_length=5u c_width=5.000000u
Xc9_75 t b9 cap_mim_2f0_m2m3_noshield c_length=5u c_width=5.000000u
Xc9_76 t b9 cap_mim_2f0_m2m3_noshield c_length=5u c_width=5.000000u
Xc9_77 t b9 cap_mim_2f0_m2m3_noshield c_length=5u c_width=5.000000u
Xc9_78 t b9 cap_mim_2f0_m2m3_noshield c_length=5u c_width=5.000000u
Xc10_79 t b10 cap_mim_2f0_m2m3_noshield c_length=5u c_width=5.000000u
Xc10_80 t b10 cap_mim_2f0_m2m3_noshield c_length=5u c_width=5.000000u
Xc10_81 t b10 cap_mim_2f0_m2m3_noshield c_length=5u c_width=5.000000u
Xc10_82 t b10 cap_mim_2f0_m2m3_noshield c_length=5u c_width=5.000000u
Xc10_83 t b10 cap_mim_2f0_m2m3_noshield c_length=5u c_width=5.000000u
Xc10_84 t b10 cap_mim_2f0_m2m3_noshield c_length=5u c_width=5.000000u
Xc10_85 t b10 cap_mim_2f0_m2m3_noshield c_length=5u c_width=5.000000u
Xc10_86 t b10 cap_mim_2f0_m2m3_noshield c_length=5u c_width=5.000000u
Xc10_87 t b10 cap_mim_2f0_m2m3_noshield c_length=5u c_width=5.000000u
Xc10_88 t b10 cap_mim_2f0_m2m3_noshield c_length=5u c_width=5.000000u
Xc10_89 t b10 cap_mim_2f0_m2m3_noshield c_length=5u c_width=5.000000u
Xc10_90 t b10 cap_mim_2f0_m2m3_noshield c_length=5u c_width=5.000000u
Xc10_91 t b10 cap_mim_2f0_m2m3_noshield c_length=5u c_width=5.000000u
Xc10_92 t b10 cap_mim_2f0_m2m3_noshield c_length=5u c_width=5.000000u
Xc10_93 t b10 cap_mim_2f0_m2m3_noshield c_length=5u c_width=5.000000u
Xc10_94 t b10 cap_mim_2f0_m2m3_noshield c_length=5u c_width=5.000000u
Xc11_95 t b11 cap_mim_2f0_m2m3_noshield c_length=5u c_width=5.000000u
Xc11_96 t b11 cap_mim_2f0_m2m3_noshield c_length=5u c_width=5.000000u
Xc11_97 t b11 cap_mim_2f0_m2m3_noshield c_length=5u c_width=5.000000u
Xc11_98 t b11 cap_mim_2f0_m2m3_noshield c_length=5u c_width=5.000000u
Xc11_99 t b11 cap_mim_2f0_m2m3_noshield c_length=5u c_width=5.000000u
Xc11_100 t b11 cap_mim_2f0_m2m3_noshield c_length=5u c_width=5.000000u
Xc11_101 t b11 cap_mim_2f0_m2m3_noshield c_length=5u c_width=5.000000u
Xc11_102 t b11 cap_mim_2f0_m2m3_noshield c_length=5u c_width=5.000000u
Xc11_103 t b11 cap_mim_2f0_m2m3_noshield c_length=5u c_width=5.000000u
Xc11_104 t b11 cap_mim_2f0_m2m3_noshield c_length=5u c_width=5.000000u
Xc11_105 t b11 cap_mim_2f0_m2m3_noshield c_length=5u c_width=5.000000u
Xc11_106 t b11 cap_mim_2f0_m2m3_noshield c_length=5u c_width=5.000000u
Xc11_107 t b11 cap_mim_2f0_m2m3_noshield c_length=5u c_width=5.000000u
Xc11_108 t b11 cap_mim_2f0_m2m3_noshield c_length=5u c_width=5.000000u
Xc11_109 t b11 cap_mim_2f0_m2m3_noshield c_length=5u c_width=5.000000u
Xc11_110 t b11 cap_mim_2f0_m2m3_noshield c_length=5u c_width=5.000000u
Xc11_111 t b11 cap_mim_2f0_m2m3_noshield c_length=5u c_width=5.000000u
Xc11_112 t b11 cap_mim_2f0_m2m3_noshield c_length=5u c_width=5.000000u
Xc11_113 t b11 cap_mim_2f0_m2m3_noshield c_length=5u c_width=5.000000u
Xc11_114 t b11 cap_mim_2f0_m2m3_noshield c_length=5u c_width=5.000000u
Xc11_115 t b11 cap_mim_2f0_m2m3_noshield c_length=5u c_width=5.000000u
Xc11_116 t b11 cap_mim_2f0_m2m3_noshield c_length=5u c_width=5.000000u
Xc11_117 t b11 cap_mim_2f0_m2m3_noshield c_length=5u c_width=5.000000u
Xc11_118 t b11 cap_mim_2f0_m2m3_noshield c_length=5u c_width=5.000000u
Xc11_119 t b11 cap_mim_2f0_m2m3_noshield c_length=5u c_width=5.000000u
Xc11_120 t b11 cap_mim_2f0_m2m3_noshield c_length=5u c_width=5.000000u
Xc11_121 t b11 cap_mim_2f0_m2m3_noshield c_length=5u c_width=5.000000u
Xc11_122 t b11 cap_mim_2f0_m2m3_noshield c_length=5u c_width=5.000000u
Xc11_123 t b11 cap_mim_2f0_m2m3_noshield c_length=5u c_width=5.000000u
Xc11_124 t b11 cap_mim_2f0_m2m3_noshield c_length=5u c_width=5.000000u
Xc11_125 t b11 cap_mim_2f0_m2m3_noshield c_length=5u c_width=5.000000u
Xc11_126 t b11 cap_mim_2f0_m2m3_noshield c_length=5u c_width=5.000000u
Xcd m bd cap_mim_2f0_m2m3_noshield c_length=5u c_width=5.000000u
Xcb t m cap_mim_2f0_m2m3_noshield c_length=5u c_width=5.082993u
.ends dac_units
