* D1 noise / offset / decision-probability testbench: staircase differential input (one value per clock cycle) from pwl files, noise injection by CMP_NA1/CMP_NA2 (see comparator.spice).
* Output: per-cycle samples of v(outp)-v(outn) at the end of each evaluate phase (python: probit fit -> offset, sigma).  Paths @PWLP@ @PWLN@ @OUT@ are replaced by the driver script.
.include ../spice/models_typical.spice
.include ../spice/comparator_params.spice
.include ../spice/comparator.spice
.include @NZFILE@
.options gmin=1e-12 reltol=1e-5 abstol=1e-14 vntol=1e-8 chgtol=1e-17 itl1=500 itl4=500
.temp 27
.param VSUP=3.3
.param TCYC=30n
.param NCYC=100
.param TCLK0=5n
.param SW_MM=0
.param sw_stat_mismatch={SW_MM}
Vdd vdd 0 {VSUP}
Vclk clk 0 PULSE(0 {VSUP} {TCLK0} 100p 100p {TCYC/2-100p} {TCYC})
.include @PWLP@
.include @PWLN@
Xc inp inn clk outp outn vdd 0 @CELL@
Cl1 outp 0 5f
Cl2 outn 0 5f
.tran 100p {NCYC*TCYC+TCLK0} 0 100p
.control
run
wrdata @OUT@ v(outp) v(outn) v(clk) i(Vdd)
.endc
.end
