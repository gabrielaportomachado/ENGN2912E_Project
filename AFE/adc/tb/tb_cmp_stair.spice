* D1 deterministic staircase testbench (no noise injection unless CMP_NA* set): one differential step per clock cycle from pwl files; per-cycle decision, delay, supply charge, input-source charge (kickback).  @PWLP@ @PWLN@ @OUT@ @CELL@ replaced by scripts/dgrun.sh.
* Output (wrdata): v(outp) v(outn) v(clk) i(Vdd) i(Vinp) i(Vinn).
.include ../spice/models_typical.spice
.include ../spice/comparator_params.spice
.include ../spice/comparator.spice
.options gmin=1e-12 reltol=1e-5 abstol=1e-14 vntol=1e-8 chgtol=1e-17 itl1=500 itl4=500
.temp 27
.param VSUP=3.3
.param TCYC=30n
.param NCYC=100
.param TCLK0=5n
.param SW_MM=0
.param sw_stat_mismatch={SW_MM}
Vdd vdd 0 {VSUP}
Vclk clk 0 PULSE(0 {VSUP} {TCLK0} 100p 100p {TCYC/2-100p} {TCYC})
.include @PWLP@
.include @PWLN@
Xc inp inn clk outp outn vdd 0 @CELL@
Cl1 outp 0 5f
Cl2 outn 0 5f
.tran 25p {NCYC*TCYC+TCLK0} 0 25p
.control
run
wrdata @OUT@ v(outp) v(outn) v(clk) i(Vdd) i(Vinp) i(Vinn)
.endc
.end
