* NGSPICE file created from FSM.ext - technology: gf180mcuD

.subckt dffsnq VNW VPW a_4883_3360# a_4479_2960# a_4470_3360# a_3430_3356# a_3430_2943#
+ a_6267_3356# a_4226_2960# a_6315_3300# a_5411_3360# a_4022_2960# a_4979_3257# a_4539_3312#
+ a_3902_3312# a_5635_3360# a_3634_2943# a_3222_3356# a_3310_3312# a_7051_2873#
X0 a_7051_2873# a_6315_3300# a_3430_3356# VPW nfet_05v0 ad=0.3586p pd=2.51u as=0.3586p ps=2.51u w=0.815u l=0.6u
X1 a_3634_2943# a_3222_3356# a_3430_3356# VPW nfet_05v0 ad=0.1782p pd=1.69u as=0.1053p ps=0.925u w=0.405u l=0.6u
X2 a_3430_2943# a_3310_3312# a_3222_3356# VNW pfet_05v0 ad=0.2249p pd=1.385u as=0.3806p ps=2.61u w=0.865u l=0.5u
X3 a_3430_3356# a_3310_3312# a_3222_3356# VPW nfet_05v0 ad=0.1053p pd=0.925u as=0.1782p ps=1.69u w=0.405u l=0.6u
X4 a_4022_2960# a_3902_3312# a_3430_3356# VPW nfet_05v0 ad=93.59999f pd=0.88u as=0.1584p ps=1.6u w=0.36u l=0.6u
X5 a_4539_3312# a_4979_3257# a_4883_3360# VPW nfet_05v0 ad=0.1989p pd=1.465u as=86.39999f ps=0.84u w=0.36u l=0.6u
X6 a_5411_3360# a_3634_2943# a_4539_3312# VPW nfet_05v0 ad=93.59999f pd=0.88u as=0.1989p ps=1.465u w=0.36u l=0.6u
X7 a_5635_3360# a_3634_2943# a_5411_3360# VNW pfet_05v0 ad=0.1826p pd=1.71u as=0.1079p ps=0.935u w=0.415u l=0.5u
X8 a_5635_3360# a_4979_3257# a_3430_2943# VNW pfet_05v0 ad=0.2028p pd=1.3u as=0.3432p ps=2.44u w=0.78u l=0.5u
X9 a_3430_3356# a_4539_3312# a_4470_3360# VPW nfet_05v0 ad=93.59999f pd=0.88u as=62.1f ps=0.705u w=0.36u l=0.6u
X10 a_4226_2960# a_3222_3356# a_4022_2960# VPW nfet_05v0 ad=93.59999f pd=0.88u as=93.59999f ps=0.88u w=0.36u l=0.6u
X11 a_3430_2943# a_4979_3257# a_4539_3312# VNW pfet_05v0 ad=0.4149p pd=2.65u as=0.1521p ps=1.105u w=0.585u l=0.5u
X12 a_4883_3360# a_4226_2960# a_3430_3356# VPW nfet_05v0 ad=86.39999f pd=0.84u as=93.59999f ps=0.88u w=0.36u l=0.6u
X13 a_6315_3300# a_5411_3360# a_3430_2943# VNW pfet_05v0 ad=0.3432p pd=2.44u as=0.3276p ps=1.62u w=0.78u l=0.5u
X14 a_4470_3360# a_3634_2943# a_4226_2960# VPW nfet_05v0 ad=62.1f pd=0.705u as=93.59999f ps=0.88u w=0.36u l=0.6u
X15 a_6315_3300# a_5411_3360# a_3430_3356# VPW nfet_05v0 ad=0.1782p pd=1.69u as=0.14985p ps=1.145u w=0.405u l=0.6u
X16 a_3634_2943# a_3222_3356# a_3430_2943# VNW pfet_05v0 ad=0.3806p pd=2.61u as=0.2249p ps=1.385u w=0.865u l=0.5u
X17 a_5411_3360# a_3222_3356# a_4539_3312# VNW pfet_05v0 ad=0.1079p pd=0.935u as=0.27805p ps=2.17u w=0.415u l=0.5u
X18 a_3430_3356# a_6315_3300# a_6267_3356# VPW nfet_05v0 ad=0.14985p pd=1.145u as=48.6f ps=0.645u w=0.405u l=0.6u
X19 a_4226_2960# a_3634_2943# a_4022_2960# VNW pfet_05v0 ad=0.19315p pd=1.27u as=0.1313p ps=1.025u w=0.505u l=0.5u
X20 a_4539_3312# a_4226_2960# a_3430_2943# VNW pfet_05v0 ad=0.1521p pd=1.105u as=0.3975p ps=2.185u w=0.585u l=0.5u
X21 a_6267_3356# a_4979_3257# a_5635_3360# VPW nfet_05v0 ad=48.6f pd=0.645u as=0.3123p ps=2.38u w=0.405u l=0.6u
X22 a_4022_2960# a_3902_3312# a_3430_2943# VNW pfet_05v0 ad=0.1313p pd=1.025u as=0.22725p ps=1.91u w=0.505u l=0.5u
X23 a_3430_2943# a_6315_3300# a_5635_3360# VNW pfet_05v0 ad=0.3276p pd=1.62u as=0.2028p ps=1.3u w=0.78u l=0.5u
X24 a_4479_2960# a_3222_3356# a_4226_2960# VNW pfet_05v0 ad=0.101p pd=0.905u as=0.19315p ps=1.27u w=0.505u l=0.5u
X25 a_5635_3360# a_3222_3356# a_5411_3360# VPW nfet_05v0 ad=0.2898p pd=2.33u as=93.59999f ps=0.88u w=0.36u l=0.6u
X26 a_7051_2873# a_6315_3300# a_3430_2943# VNW pfet_05v0 ad=0.6561p pd=3.51u as=0.5346p ps=3.31u w=1.215u l=0.5u
X27 a_3430_2943# a_4539_3312# a_4479_2960# VNW pfet_05v0 ad=0.3975p pd=2.185u as=0.101p ps=0.905u w=0.505u l=0.5u
C0 a_4979_3257# a_3222_3356# 0.07762f
C1 a_5411_3360# a_6267_3356# 0.00413f
C2 a_5411_3360# a_3430_2943# 0.07341f
C3 a_4226_2960# a_4479_2960# 0.00215f
C4 a_4226_2960# a_4539_3312# 0.38667f
C5 VNW a_3310_3312# 0.13342f
C6 a_3430_2943# a_3902_3312# 0.00494f
C7 VNW a_3430_3356# 0.00946f
C8 a_4979_3257# a_4539_3312# 0.07298f
C9 a_4226_2960# a_4470_3360# 0
C10 a_3430_2943# a_7051_2873# 0.28218f
C11 a_5411_3360# a_6315_3300# 0.51404f
C12 a_3430_2943# a_6267_3356# 0
C13 a_3634_2943# a_3310_3312# 0.00131f
C14 a_5411_3360# a_4979_3257# 0.0706f
C15 a_3634_2943# a_3430_3356# 1.08287f
C16 a_4226_2960# a_3902_3312# 0
C17 a_3222_3356# a_3310_3312# 0.70196f
C18 a_3222_3356# a_3430_3356# 0.29459f
C19 a_7051_2873# a_6315_3300# 0.17947f
C20 a_5635_3360# VNW 0.04382f
C21 a_4022_2960# a_3430_3356# 0.05001f
C22 a_3430_2943# a_6315_3300# 0.35131f
C23 a_4539_3312# a_3430_3356# 0.02825f
C24 a_3634_2943# VNW 0.40096f
C25 a_3430_2943# a_4226_2960# 0.03968f
C26 VNW a_3222_3356# 0.90809f
C27 a_5635_3360# a_3634_2943# 0.05668f
C28 a_4979_3257# a_3430_2943# 0.12782f
C29 a_4470_3360# a_3430_3356# 0.00364f
C30 a_4022_2960# VNW 0.01368f
C31 a_5635_3360# a_3222_3356# 0.00597f
C32 a_5411_3360# a_3430_3356# 1.19047f
C33 VNW a_4539_3312# 0.21951f
C34 a_3634_2943# a_3222_3356# 0.47313f
C35 a_5635_3360# a_4539_3312# 0
C36 a_4022_2960# a_3634_2943# 0.42776f
C37 a_3902_3312# a_3430_3356# 0.06788f
C38 a_4979_3257# a_6315_3300# 0.08929f
C39 a_4979_3257# a_4226_2960# 0.06324f
C40 a_4022_2960# a_3222_3356# 0.0157f
C41 a_7051_2873# a_3430_3356# 0.13127f
C42 a_5411_3360# VNW 0.20903f
C43 a_3634_2943# a_4539_3312# 0.31725f
C44 a_3222_3356# a_4479_2960# 0.00838f
C45 a_5411_3360# a_5635_3360# 0.56917f
C46 a_4539_3312# a_3222_3356# 0.84088f
C47 a_3430_2943# a_3310_3312# 0.02223f
C48 a_3430_2943# a_3430_3356# 0.01381f
C49 a_3634_2943# a_4470_3360# 0.00269f
C50 VNW a_3902_3312# 0.16142f
C51 VNW a_7051_2873# 0.03162f
C52 a_4883_3360# a_3634_2943# 0.00762f
C53 a_4539_3312# a_4479_2960# 0
C54 a_5411_3360# a_3634_2943# 0.154f
C55 a_5411_3360# a_3222_3356# 0.15368f
C56 a_3430_3356# a_6315_3300# 0.13908f
C57 a_3430_2943# VNW 0.53642f
C58 a_3634_2943# a_3902_3312# 0.4001f
C59 a_4226_2960# a_3430_3356# 0.06133f
C60 a_5635_3360# a_6267_3356# 0.0012f
C61 a_3430_2943# a_5635_3360# 0.20863f
C62 a_3902_3312# a_3222_3356# 0.0927f
C63 a_3634_2943# a_7051_2873# 0
C64 a_4883_3360# a_4539_3312# 0.00275f
C65 a_4022_2960# a_3902_3312# 0.1081f
C66 a_4979_3257# a_3430_3356# 0.01045f
C67 a_7051_2873# a_3222_3356# 0
C68 a_5411_3360# a_4539_3312# 0.15287f
C69 a_3430_2943# a_3634_2943# 0.62458f
C70 VNW a_6315_3300# 0.32346f
C71 a_4226_2960# VNW 0.22464f
C72 a_3430_2943# a_3222_3356# 1.41458f
C73 a_5635_3360# a_6315_3300# 0.00955f
C74 a_4979_3257# VNW 0.81105f
C75 a_4979_3257# a_5635_3360# 0.30222f
C76 a_3430_2943# a_4539_3312# 0.01626f
C77 a_3634_2943# a_6315_3300# 0
C78 a_4226_2960# a_3634_2943# 0.86961f
C79 a_5411_3360# a_7051_2873# 0
C80 a_3222_3356# a_6315_3300# 0
C81 a_4226_2960# a_3222_3356# 0.20702f
C82 a_3310_3312# a_3430_3356# 0.02287f
C83 a_4979_3257# a_3634_2943# 0.0839f
C84 a_4226_2960# a_4022_2960# 0.06821f
C85 VNW VPW 6.37108f
C86 a_7051_2873# VPW 0.10557f
C87 a_6315_3300# VPW 0.58406f
C88 a_5635_3360# VPW 0.04999f
C89 a_5411_3360# VPW 0.43408f
C90 a_3430_2943# VPW 0.83584f
C91 a_4022_2960# VPW 0.01977f
C92 a_4979_3257# VPW 0.71025f
C93 a_4226_2960# VPW 0.30208f
C94 a_4539_3312# VPW 0.28651f
C95 a_3902_3312# VPW 0.24718f
C96 a_3634_2943# VPW 1.21246f
C97 a_3430_3356# VPW 1.53117f
C98 a_3310_3312# VPW 0.2938f
C99 a_3222_3356# VPW 1.31514f
.ends

.subckt mux21 VNW VPW a_n2035_3346# a_n2339_2762# a_n2427_3346# a_n2807_3163# a_n2394_2806#
+ a_n1987_2762# a_n2687_2806# a_n2687_3290# a_n2035_2806# a_n2547_3163# a_n2379_3163#
+ a_n2895_3290#
X0 a_n2035_2806# a_n2379_3163# a_n2807_3163# VNW pfet_05v0 ad=73.8f pd=0.855u as=0.1599p ps=1.135u w=0.615u l=0.5u
X1 a_n2687_2806# a_n1987_2762# a_n2035_2806# VNW pfet_05v0 ad=0.1599p pd=1.135u as=73.8f ps=0.855u w=0.615u l=0.5u
X2 a_n2687_3290# a_n1987_2762# a_n2035_3346# VPW nfet_05v0 ad=93.59999f pd=0.88u as=43.2f ps=0.6u w=0.36u l=0.6u
X3 a_n2427_3346# a_n2547_3163# a_n2687_3290# VPW nfet_05v0 ad=43.2f pd=0.6u as=0.218p ps=1.52u w=0.36u l=0.6u
X4 a_n2339_2762# a_n2379_3163# a_n2687_3290# VPW nfet_05v0 ad=0.1584p pd=1.6u as=93.59999f ps=0.88u w=0.36u l=0.6u
X5 a_n2807_3163# a_n2339_2762# a_n2394_2806# VNW pfet_05v0 ad=0.1599p pd=1.135u as=84.55f ps=0.89u w=0.615u l=0.5u
X6 a_n2687_2806# a_n2807_3163# a_n2895_3290# VNW pfet_05v0 ad=0.42982p pd=2.185u as=0.5368p ps=3.32u w=1.22u l=0.5u
X7 a_n2807_3163# a_n2379_3163# a_n2427_3346# VPW nfet_05v0 ad=93.59999f pd=0.88u as=43.2f ps=0.6u w=0.36u l=0.6u
X8 a_n2035_3346# a_n2339_2762# a_n2807_3163# VPW nfet_05v0 ad=43.2f pd=0.6u as=93.59999f ps=0.88u w=0.36u l=0.6u
X9 a_n2339_2762# a_n2379_3163# a_n2687_2806# VNW pfet_05v0 ad=0.2706p pd=2.11u as=0.1599p ps=1.135u w=0.615u l=0.5u
X10 a_n2687_3290# a_n2807_3163# a_n2895_3290# VPW nfet_05v0 ad=0.218p pd=1.52u as=0.3608p ps=2.52u w=0.82u l=0.6u
X11 a_n2394_2806# a_n2547_3163# a_n2687_2806# VNW pfet_05v0 ad=84.55f pd=0.89u as=0.42982p ps=2.185u w=0.615u l=0.5u
C0 a_n2379_3163# a_n2394_2806# 0
C1 a_n2339_2762# a_n1987_2762# 0.44871f
C2 a_n2339_2762# a_n2807_3163# 0.03132f
C3 a_n2547_3163# a_n2687_3290# 0.01931f
C4 a_n1987_2762# a_n2687_2806# 0.02643f
C5 VNW a_n2379_3163# 0.35854f
C6 a_n2807_3163# a_n2687_2806# 0.57837f
C7 a_n2547_3163# a_n2895_3290# 0.00111f
C8 a_n2807_3163# a_n1987_2762# 0.00457f
C9 a_n2547_3163# a_n2394_2806# 0
C10 a_n2339_2762# a_n2379_3163# 0.31909f
C11 a_n2035_2806# a_n2339_2762# 0
C12 a_n2687_3290# a_n2895_3290# 0.07969f
C13 a_n2687_2806# a_n2379_3163# 0.20342f
C14 a_n2035_2806# a_n2687_2806# 0.00486f
C15 a_n2547_3163# VNW 0.19864f
C16 a_n2035_3346# a_n2687_3290# 0.0022f
C17 a_n1987_2762# a_n2379_3163# 0.61564f
C18 a_n2687_3290# VNW 0.00651f
C19 a_n2807_3163# a_n2379_3163# 0.22045f
C20 a_n2035_2806# a_n2807_3163# 0.00106f
C21 a_n2339_2762# a_n2547_3163# 0.06637f
C22 a_n2807_3163# a_n2427_3346# 0.00317f
C23 a_n2687_2806# a_n2547_3163# 0.01544f
C24 VNW a_n2895_3290# 0.03019f
C25 a_n2339_2762# a_n2687_3290# 0.30506f
C26 a_n2687_2806# a_n2687_3290# 0.01065f
C27 a_n1987_2762# a_n2547_3163# 0
C28 a_n2035_2806# a_n2379_3163# 0.00276f
C29 a_n2807_3163# a_n2547_3163# 0.45783f
C30 a_n1987_2762# a_n2687_3290# 0.03158f
C31 a_n2339_2762# a_n2394_2806# 0
C32 a_n2807_3163# a_n2687_3290# 0.53787f
C33 a_n2687_2806# a_n2895_3290# 0.09438f
C34 a_n2035_3346# a_n2339_2762# 0.00166f
C35 a_n2687_2806# a_n2394_2806# 0.0019f
C36 a_n2339_2762# VNW 0.27449f
C37 a_n2547_3163# a_n2379_3163# 0.3671f
C38 a_n2807_3163# a_n2895_3290# 0.13298f
C39 a_n2687_2806# VNW 0.16121f
C40 a_n2807_3163# a_n2394_2806# 0.00556f
C41 a_n2427_3346# a_n2547_3163# 0
C42 a_n2035_3346# a_n2807_3163# 0.00101f
C43 a_n2687_3290# a_n2379_3163# 0.04663f
C44 a_n1987_2762# VNW 0.18121f
C45 a_n2427_3346# a_n2687_3290# 0
C46 a_n2807_3163# VNW 0.16283f
C47 a_n2339_2762# a_n2687_2806# 0.14217f
C48 VNW VPW 2.50194f
C49 a_n2687_2806# VPW 0.34621f
C50 a_n1987_2762# VPW 0.29252f
C51 a_n2339_2762# VPW 0.4399f
C52 a_n2379_3163# VPW 0.64969f
C53 a_n2547_3163# VPW 0.31807f
C54 a_n2687_3290# VPW 0.57909f
C55 a_n2895_3290# VPW 0.11309f
C56 a_n2807_3163# VPW 0.3249f
.ends

.subckt dffrnq VNW VPW a_1667_2471# a_563_2471# a_311_2787# a_395_2471# a_n649_2466#
+ a_2776_2384# a_1772_2427# a_1355_2471# a_n649_2787# a_2148_2471# a_611_2339# a_n857_2466#
+ a_n197_2617# a_n445_2787# a_415_2738# a_107_2787# a_n97_2787# a_n769_2422#
X0 a_n649_2787# a_n769_2422# a_n857_2466# VNW pfet_05v0 ad=0.2249p pd=1.385u as=0.3806p ps=2.61u w=0.865u l=0.5u
X1 a_311_2787# a_n857_2466# a_107_2787# VNW pfet_05v0 ad=0.2028p pd=1.3u as=0.2028p ps=1.3u w=0.78u l=0.5u
X2 a_2148_2471# a_611_2339# a_n649_2466# VPW nfet_05v0 ad=0.134p pd=1.1u as=0.1224p ps=1.04u w=0.36u l=0.6u
X3 a_1355_2471# a_n445_2787# a_415_2738# VPW nfet_05v0 ad=0.2007p pd=1.475u as=0.2007p ps=1.475u w=0.36u l=0.6u
X4 a_107_2787# a_n857_2466# a_n97_2787# VPW nfet_05v0 ad=93.59999f pd=0.88u as=93.59999f ps=0.88u w=0.36u l=0.6u
X5 a_311_2787# a_611_2339# a_n649_2787# VNW pfet_05v0 ad=0.3432p pd=2.44u as=0.45p ps=2.02u w=0.78u l=0.5u
X6 a_n649_2466# a_611_2339# a_563_2471# VPW nfet_05v0 ad=0.2016p pd=1.48u as=43.2f ps=0.6u w=0.36u l=0.6u
X7 a_2776_2384# a_1772_2427# a_n649_2466# VPW nfet_05v0 ad=0.3586p pd=2.51u as=0.3586p ps=2.51u w=0.815u l=0.6u
X8 a_n649_2787# a_1772_2427# a_1667_2471# VNW pfet_05v0 ad=0.29465p pd=1.74u as=0.1313p ps=1.025u w=0.505u l=0.5u
X9 a_107_2787# a_n445_2787# a_n97_2787# VNW pfet_05v0 ad=0.2028p pd=1.3u as=0.2028p ps=1.3u w=0.78u l=0.5u
X10 a_n97_2787# a_n197_2617# a_n649_2466# VPW nfet_05v0 ad=93.59999f pd=0.88u as=0.1584p ps=1.6u w=0.36u l=0.6u
X11 a_563_2471# a_415_2738# a_395_2471# VPW nfet_05v0 ad=43.2f pd=0.6u as=43.2f ps=0.6u w=0.36u l=0.6u
X12 a_n649_2787# a_1355_2471# a_1772_2427# VNW pfet_05v0 ad=0.44p pd=2.88u as=0.26p ps=1.52u w=1u l=0.5u
X13 a_395_2471# a_n445_2787# a_107_2787# VPW nfet_05v0 ad=43.2f pd=0.6u as=93.59999f ps=0.88u w=0.36u l=0.6u
X14 a_415_2738# a_107_2787# a_n649_2787# VNW pfet_05v0 ad=0.2424p pd=1.465u as=0.2222p ps=1.89u w=0.505u l=0.5u
X15 a_2776_2384# a_1772_2427# a_n649_2787# VNW pfet_05v0 ad=0.5346p pd=3.31u as=0.5346p ps=3.31u w=1.215u l=0.5u
X16 a_n649_2466# a_1772_2427# a_1667_2471# VPW nfet_05v0 ad=0.1224p pd=1.04u as=94.5f ps=0.885u w=0.36u l=0.6u
X17 a_n97_2787# a_n197_2617# a_n649_2787# VNW pfet_05v0 ad=0.2028p pd=1.3u as=0.3432p ps=2.44u w=0.78u l=0.5u
X18 a_n445_2787# a_n857_2466# a_n649_2787# VNW pfet_05v0 ad=0.3806p pd=2.61u as=0.2249p ps=1.385u w=0.865u l=0.5u
X19 a_n649_2787# a_415_2738# a_311_2787# VNW pfet_05v0 ad=0.45p pd=2.02u as=0.2028p ps=1.3u w=0.78u l=0.5u
X20 a_n649_2466# a_n769_2422# a_n857_2466# VPW nfet_05v0 ad=0.1053p pd=0.925u as=0.1782p ps=1.69u w=0.405u l=0.6u
X21 a_1667_2471# a_n857_2466# a_1355_2471# VPW nfet_05v0 ad=94.5f pd=0.885u as=0.2007p ps=1.475u w=0.36u l=0.6u
X22 a_415_2738# a_107_2787# a_n649_2466# VPW nfet_05v0 ad=0.2007p pd=1.475u as=0.2016p ps=1.48u w=0.36u l=0.6u
X23 a_n445_2787# a_n857_2466# a_n649_2466# VPW nfet_05v0 ad=0.1782p pd=1.69u as=0.1053p ps=0.925u w=0.405u l=0.6u
X24 a_1355_2471# a_n857_2466# a_415_2738# VNW pfet_05v0 ad=0.25375p pd=1.51u as=0.2424p ps=1.465u w=0.505u l=0.5u
X25 a_1772_2427# a_1355_2471# a_2148_2471# VPW nfet_05v0 ad=0.176p pd=1.68u as=0.134p ps=1.1u w=0.4u l=0.6u
X26 a_1667_2471# a_n445_2787# a_1355_2471# VNW pfet_05v0 ad=0.1313p pd=1.025u as=0.25375p ps=1.51u w=0.505u l=0.5u
X27 a_1772_2427# a_611_2339# a_n649_2787# VNW pfet_05v0 ad=0.26p pd=1.52u as=0.29465p ps=1.74u w=1u l=0.5u
C0 a_311_2787# a_n445_2787# 0.009f
C1 a_n197_2617# a_n445_2787# 0.32879f
C2 a_611_2339# a_n649_2787# 0.03498f
C3 a_n649_2787# a_1355_2471# 1.11667f
C4 VNW a_n649_2787# 0.50089f
C5 a_n649_2466# a_n649_2787# 0.01338f
C6 a_n857_2466# a_n445_2787# 0.53697f
C7 a_107_2787# a_n649_2787# 0.11921f
C8 a_n769_2422# a_n857_2466# 0.6696f
C9 a_611_2339# a_1355_2471# 0.09434f
C10 a_n197_2617# a_n97_2787# 0.08286f
C11 VNW a_611_2339# 0.32949f
C12 VNW a_1355_2471# 0.21243f
C13 a_n649_2466# a_611_2339# 0.44197f
C14 a_n649_2466# a_1355_2471# 0.03047f
C15 a_611_2339# a_107_2787# 0.0832f
C16 a_107_2787# a_1355_2471# 0.00123f
C17 VNW a_n649_2466# 0.0106f
C18 a_1772_2427# a_n857_2466# 0.01904f
C19 VNW a_107_2787# 0.24136f
C20 a_n649_2466# a_107_2787# 0.04356f
C21 a_1667_2471# a_n857_2466# 0.00367f
C22 a_n857_2466# a_n97_2787# 0.01185f
C23 a_n857_2466# a_2776_2384# 0
C24 a_n649_2466# a_563_2471# 0.0019f
C25 a_107_2787# a_563_2471# 0
C26 a_415_2738# a_n445_2787# 0.8821f
C27 a_n649_2466# a_395_2471# 0.0017f
C28 a_107_2787# a_395_2471# 0
C29 a_n649_2787# a_311_2787# 0.28263f
C30 a_n197_2617# a_n649_2787# 0.00937f
C31 a_611_2339# a_311_2787# 0.02104f
C32 a_n857_2466# a_n649_2787# 0.41709f
C33 VNW a_311_2787# 0.01627f
C34 VNW a_n197_2617# 0.12821f
C35 a_2148_2471# a_1772_2427# 0.00177f
C36 a_n649_2466# a_n197_2617# 0.06462f
C37 a_107_2787# a_311_2787# 0.66083f
C38 a_n197_2617# a_107_2787# 0
C39 a_611_2339# a_n857_2466# 0.0801f
C40 a_n857_2466# a_1355_2471# 0.0428f
C41 VNW a_n857_2466# 1.28735f
C42 a_n649_2466# a_n857_2466# 0.29126f
C43 a_107_2787# a_n857_2466# 0.08126f
C44 a_n769_2422# a_n445_2787# 0.00276f
C45 a_1772_2427# a_n445_2787# 0.02046f
C46 a_1667_2471# a_n445_2787# 0.27749f
C47 a_n97_2787# a_n445_2787# 0.40164f
C48 a_415_2738# a_n649_2787# 0.09419f
C49 a_1667_2471# a_1772_2427# 0.11606f
C50 a_415_2738# a_611_2339# 0.07929f
C51 a_415_2738# a_1355_2471# 0.05672f
C52 a_611_2339# a_2148_2471# 0.01068f
C53 VNW a_415_2738# 0.14901f
C54 a_1772_2427# a_2776_2384# 0.10944f
C55 a_n649_2466# a_415_2738# 0.01387f
C56 a_415_2738# a_107_2787# 0.93419f
C57 a_n857_2466# a_311_2787# 0.007f
C58 a_n197_2617# a_n857_2466# 0.09411f
C59 a_n649_2787# a_n445_2787# 0.45627f
C60 a_n769_2422# a_n649_2787# 0.02303f
C61 a_611_2339# a_n445_2787# 0.07873f
C62 a_n445_2787# a_1355_2471# 0.51037f
C63 VNW a_n445_2787# 0.34128f
C64 a_1772_2427# a_n649_2787# 0.10205f
C65 a_n649_2466# a_n445_2787# 1.20207f
C66 a_107_2787# a_n445_2787# 0.36196f
C67 a_1667_2471# a_n649_2787# 0.00217f
C68 a_n769_2422# VNW 0.1337f
C69 a_n649_2787# a_n97_2787# 0
C70 a_n769_2422# a_n649_2466# 0.02195f
C71 a_n649_2787# a_2776_2384# 0.14934f
C72 a_611_2339# a_1772_2427# 0.33647f
C73 a_1772_2427# a_1355_2471# 0.63332f
C74 a_415_2738# a_311_2787# 0.02667f
C75 a_563_2471# a_n445_2787# 0.00227f
C76 VNW a_1772_2427# 0.35472f
C77 a_1667_2471# a_611_2339# 0.03878f
C78 a_n649_2466# a_1772_2427# 0.185f
C79 a_1667_2471# a_1355_2471# 0.11969f
C80 VNW a_1667_2471# 0.02016f
C81 VNW a_n97_2787# 0.01023f
C82 a_n649_2466# a_1667_2471# 0.1285f
C83 a_611_2339# a_2776_2384# 0
C84 a_n649_2466# a_n97_2787# 0.05215f
C85 a_2776_2384# a_1355_2471# 0.01436f
C86 a_107_2787# a_n97_2787# 0.04844f
C87 VNW a_2776_2384# 0.03444f
C88 a_n649_2466# a_2776_2384# 0.1134f
C89 a_415_2738# a_n857_2466# 0.05539f
C90 a_395_2471# a_n445_2787# 0.00207f
C91 VNW VPW 6.06621f
C92 a_2776_2384# VPW 0.11476f
C93 a_n649_2466# VPW 1.26186f
C94 a_1667_2471# VPW 0.01697f
C95 a_1772_2427# VPW 0.62251f
C96 a_1355_2471# VPW 0.37166f
C97 a_611_2339# VPW 1.36673f
C98 a_311_2787# VPW 0.01297f
C99 a_107_2787# VPW 0.29173f
C100 a_n97_2787# VPW 0.02321f
C101 a_415_2738# VPW 0.27904f
C102 a_n197_2617# VPW 0.25343f
C103 a_n445_2787# VPW 0.68441f
C104 a_n649_2787# VPW 0.80211f
C105 a_n769_2422# VPW 0.29458f
C106 a_n857_2466# VPW 1.43686f
.ends

.subckt nor2_1 a_n5117_4170# a_n4805_3759# a_n5029_3759# a_n5117_3803# a_n4909_3803#
+ a_n4929_4170# w_n5239_4050# VSUBS
X0 a_n5117_3803# a_n4805_3759# a_n4909_3803# VSUBS nfet_05v0 ad=0.2486p pd=2.01u as=0.1469p ps=1.085u w=0.565u l=0.6u
X1 a_n4929_4170# a_n5029_3759# a_n5117_4170# w_n5239_4050# pfet_05v0 ad=0.4087p pd=1.89u as=0.5368p ps=3.32u w=1.22u l=0.5u
X2 a_n4909_3803# a_n5029_3759# a_n5117_3803# VSUBS nfet_05v0 ad=0.1469p pd=1.085u as=0.2486p ps=2.01u w=0.565u l=0.6u
X3 a_n4909_3803# a_n4805_3759# a_n4929_4170# w_n5239_4050# pfet_05v0 ad=0.5368p pd=3.32u as=0.4087p ps=1.89u w=1.22u l=0.5u
C0 a_n5029_3759# a_n4805_3759# 0.03781f
C1 a_n5117_3803# w_n5239_4050# 0.01397f
C2 w_n5239_4050# a_n4805_3759# 0.12879f
C3 a_n4909_3803# a_n5029_3759# 0.37841f
C4 a_n4909_3803# w_n5239_4050# 0.0217f
C5 a_n5029_3759# w_n5239_4050# 0.1288f
C6 a_n4929_4170# a_n5117_4170# 0.01396f
C7 a_n5117_3803# a_n5117_4170# 0.02578f
C8 a_n5117_4170# a_n4805_3759# 0.02269f
C9 a_n4929_4170# a_n5117_3803# 0
C10 a_n4909_3803# a_n5117_4170# 0.11792f
C11 a_n5117_3803# a_n4805_3759# 0.13941f
C12 a_n5117_4170# a_n5029_3759# 0.25532f
C13 a_n5117_4170# w_n5239_4050# 0.09389f
C14 a_n4909_3803# a_n4929_4170# 0.02369f
C15 a_n4909_3803# a_n5117_3803# 0.10123f
C16 a_n4909_3803# a_n4805_3759# 0.46284f
C17 a_n4929_4170# a_n5029_3759# 0.00898f
C18 a_n5117_3803# a_n5029_3759# 0.04335f
C19 a_n5117_3803# VSUBS 0.33074f
C20 a_n4909_3803# VSUBS 0.06183f
C21 a_n5117_4170# VSUBS 0.21851f
C22 a_n4805_3759# VSUBS 0.32338f
C23 a_n5029_3759# VSUBS 0.33451f
C24 w_n5239_4050# VSUBS 1.31158f
.ends

.subckt nor2_2 a_n3913_1897# a_n3601_1486# a_n3705_1530# a_n3725_1897# a_n3825_1486#
+ w_n4035_1777# a_n3913_1530# VSUBS
X0 a_n3725_1897# a_n3825_1486# a_n3913_1897# w_n4035_1777# pfet_05v0 ad=0.4087p pd=1.89u as=0.5368p ps=3.32u w=1.22u l=0.5u
X1 a_n3705_1530# a_n3825_1486# a_n3913_1530# VSUBS nfet_05v0 ad=0.1469p pd=1.085u as=0.2486p ps=2.01u w=0.565u l=0.6u
X2 a_n3913_1530# a_n3601_1486# a_n3705_1530# VSUBS nfet_05v0 ad=0.2486p pd=2.01u as=0.1469p ps=1.085u w=0.565u l=0.6u
X3 a_n3705_1530# a_n3601_1486# a_n3725_1897# w_n4035_1777# pfet_05v0 ad=0.5368p pd=3.32u as=0.4087p ps=1.89u w=1.22u l=0.5u
C0 a_n3705_1530# a_n3601_1486# 0.57973f
C1 w_n4035_1777# a_n3705_1530# 0.01867f
C2 a_n3725_1897# a_n3825_1486# 0.00898f
C3 a_n3913_1530# a_n3705_1530# 0.08687f
C4 a_n3913_1897# a_n3705_1530# 0.11792f
C5 a_n3825_1486# a_n3705_1530# 0.37841f
C6 a_n3725_1897# a_n3705_1530# 0.02369f
C7 w_n4035_1777# a_n3601_1486# 0.13462f
C8 a_n3913_1530# a_n3601_1486# 0.16863f
C9 a_n3913_1897# a_n3601_1486# 0.02804f
C10 w_n4035_1777# a_n3913_1530# 0.01057f
C11 w_n4035_1777# a_n3913_1897# 0.09154f
C12 a_n3913_1530# a_n3913_1897# 0.02322f
C13 a_n3825_1486# a_n3601_1486# 0.03781f
C14 w_n4035_1777# a_n3825_1486# 0.1288f
C15 a_n3913_1530# a_n3825_1486# 0.04335f
C16 a_n3825_1486# a_n3913_1897# 0.25532f
C17 a_n3913_1530# a_n3725_1897# 0
C18 a_n3725_1897# a_n3913_1897# 0.01396f
C19 a_n3913_1530# VSUBS 0.33149f
C20 a_n3705_1530# VSUBS 0.06f
C21 a_n3913_1897# VSUBS 0.22019f
C22 a_n3601_1486# VSUBS 0.33415f
C23 a_n3825_1486# VSUBS 0.33451f
C24 w_n4035_1777# VSUBS 1.24009f
.ends

.subckt inv1 VNW VPW a_142_558# a_210_110# a_122_154# a_330_154#
X0 a_330_154# a_210_110# a_122_154# VPW nfet_05v0 ad=0.3608p pd=2.52u as=0.3608p ps=2.52u w=0.82u l=0.6u
X1 a_330_154# a_210_110# a_142_558# VNW pfet_05v0 ad=0.5368p pd=3.32u as=0.5368p ps=3.32u w=1.22u l=0.5u
C0 a_122_154# a_210_110# 0.0533f
C1 VNW a_142_558# 0.07626f
C2 a_330_154# a_142_558# 0.13738f
C3 VNW a_330_154# 0.0222f
C4 a_210_110# a_142_558# 0.04185f
C5 a_122_154# a_142_558# 0.02563f
C6 VNW a_210_110# 0.13776f
C7 a_210_110# a_330_154# 0.2622f
C8 VNW a_122_154# 0.01134f
C9 a_122_154# a_330_154# 0.1153f
C10 VNW VPW 0.96348f
C11 a_122_154# VPW 0.2316f
C12 a_330_154# VPW 0.1134f
C13 a_142_558# VPW 0.18114f
C14 a_210_110# VPW 0.34198f
.ends

.subckt FSM MODE RSTn VSS CLK VDD TREAT_EN REC_EN
Xdffsnq_0 VDD VSS dffsnq_0/a_4883_3360# dffsnq_0/a_4479_2960# dffsnq_0/a_4470_3360#
+ VSS VDD dffsnq_0/a_6267_3356# dffsnq_0/a_4226_2960# dffsnq_0/a_6315_3300# dffsnq_0/a_5411_3360#
+ dffsnq_0/a_4022_2960# RSTn dffsnq_0/a_4539_3312# m2_n1268_1517# dffsnq_0/a_5635_3360#
+ dffsnq_0/a_3634_2943# dffsnq_0/a_3222_3356# CLK m2_n2888_1381# dffsnq
Xmux21_0 VDD VSS mux21_0/a_n2035_3346# mux21_0/a_n2339_2762# mux21_0/a_n2427_3346#
+ mux21_0/a_n2807_3163# mux21_0/a_n2394_2806# REC_EN VDD VSS mux21_0/a_n2035_2806#
+ TREAT_EN MODE m2_n1268_1517# mux21
Xdffrnq_0 VDD VSS dffrnq_0/a_1667_2471# dffrnq_0/a_563_2471# dffrnq_0/a_311_2787#
+ dffrnq_0/a_395_2471# VSS REC_EN dffrnq_0/a_1772_2427# dffrnq_0/a_1355_2471# VDD
+ dffrnq_0/a_2148_2471# RSTn dffrnq_0/a_n857_2466# m2_n1118_2715# dffrnq_0/a_n445_2787#
+ dffrnq_0/a_415_2738# dffrnq_0/a_107_2787# dffrnq_0/a_n97_2787# CLK dffrnq
Xnor2_1_0 VDD REC_EN m2_n2888_1381# VSS TREAT_EN nor2_1_0/a_n4929_4170# VDD VSS nor2_1
Xnor2_2_0 VDD TREAT_EN m2_n1118_2715# nor2_2_0/a_n3725_1897# m1_n1940_2465# VDD VSS
+ VSS nor2_2
Xinv1_0 VDD VSS VDD MODE VSS m1_n1940_2465# inv1
C0 mux21_0/a_n2035_3346# MODE 0
C1 dffsnq_0/a_3222_3356# dffrnq_0/a_n445_2787# 0
C2 RSTn dffrnq_0/a_415_2738# 0
C3 CLK m2_n1118_2715# 0.15521f
C4 dffrnq_0/a_2148_2471# m2_n2888_1381# 0
C5 VDD dffsnq_0/a_5411_3360# 0.00119f
C6 dffsnq_0/a_5635_3360# dffsnq_0/a_5411_3360# -0
C7 TREAT_EN dffrnq_0/a_n857_2466# 0.0154f
C8 REC_EN dffsnq_0/a_4479_2960# 0
C9 m1_n1940_2465# dffrnq_0/a_n857_2466# 0
C10 dffrnq_0/a_395_2471# REC_EN 0
C11 REC_EN RSTn 0.04521f
C12 dffsnq_0/a_4226_2960# VDD 0
C13 REC_EN dffrnq_0/a_415_2738# 0.03883f
C14 mux21_0/a_n2427_3346# MODE 0
C15 dffsnq_0/a_4539_3312# CLK 0
C16 dffsnq_0/a_4470_3360# CLK 0
C17 mux21_0/a_n2035_2806# m2_n2888_1381# 0.0019f
C18 dffsnq_0/a_3634_2943# dffrnq_0/a_n445_2787# 0
C19 VDD dffrnq_0/a_n97_2787# -0
C20 dffrnq_0/a_1772_2427# RSTn 0.00696f
C21 mux21_0/a_n2339_2762# VDD 0.07278f
C22 m2_n1268_1517# m2_n2888_1381# 0.32309f
C23 dffrnq_0/a_107_2787# RSTn 0
C24 dffsnq_0/a_6315_3300# dffrnq_0/a_1355_2471# 0
C25 m2_n1268_1517# m2_n1118_2715# 0.01606f
C26 VDD CLK 0.07919f
C27 MODE m2_n2888_1381# 0.03114f
C28 m2_n1118_2715# MODE 0.00199f
C29 REC_EN TREAT_EN 0.96508f
C30 dffsnq_0/a_4226_2960# dffrnq_0/a_n445_2787# 0
C31 REC_EN mux21_0/a_n2807_3163# 0
C32 m1_n1940_2465# REC_EN 0.04809f
C33 dffsnq_0/a_4022_2960# m2_n2888_1381# 0.01245f
C34 dffrnq_0/a_1772_2427# REC_EN 0.06518f
C35 dffsnq_0/a_4022_2960# m2_n1118_2715# 0.0012f
C36 REC_EN dffrnq_0/a_107_2787# 0.04683f
C37 dffsnq_0/a_5411_3360# dffrnq_0/a_1355_2471# 0.00389f
C38 m2_n1268_1517# dffsnq_0/a_4539_3312# 0.00178f
C39 dffrnq_0/a_n445_2787# dffrnq_0/a_n97_2787# -0
C40 m1_n1940_2465# TREAT_EN 0.09288f
C41 TREAT_EN mux21_0/a_n2807_3163# 0.0216f
C42 m1_n1940_2465# mux21_0/a_n2807_3163# 0.00362f
C43 mux21_0/a_n2035_3346# REC_EN 0
C44 dffrnq_0/a_n857_2466# m2_n2888_1381# 0.00435f
C45 TREAT_EN dffrnq_0/a_107_2787# 0
C46 dffrnq_0/a_n857_2466# m2_n1118_2715# 0.09109f
C47 CLK dffrnq_0/a_n445_2787# 0.00219f
C48 dffrnq_0/a_563_2471# RSTn 0
C49 m2_n1268_1517# VDD 0.07483f
C50 mux21_0/a_n2035_3346# TREAT_EN 0
C51 m2_n2888_1381# dffsnq_0/a_4479_2960# 0.00107f
C52 VDD MODE 0.02431f
C53 dffsnq_0/a_3222_3356# CLK 0.04043f
C54 dffrnq_0/a_395_2471# m2_n2888_1381# 0
C55 REC_EN nor2_1_0/a_n4929_4170# 0.00277f
C56 RSTn m2_n2888_1381# 0.08042f
C57 dffsnq_0/a_4539_3312# dffrnq_0/a_n857_2466# 0
C58 dffsnq_0/a_4022_2960# VDD -0
C59 m2_n1118_2715# RSTn 0
C60 dffrnq_0/a_563_2471# REC_EN 0
C61 dffrnq_0/a_415_2738# m2_n2888_1381# 0.00326f
C62 m2_n1118_2715# dffrnq_0/a_415_2738# 0.00111f
C63 TREAT_EN mux21_0/a_n2427_3346# 0
C64 TREAT_EN nor2_1_0/a_n4929_4170# 0.00385f
C65 REC_EN m2_n2888_1381# 0.09711f
C66 REC_EN m2_n1118_2715# 0.40328f
C67 VDD dffrnq_0/a_n857_2466# 0.00327f
C68 dffsnq_0/a_4539_3312# RSTn 0.00173f
C69 dffsnq_0/a_3634_2943# CLK 0.00346f
C70 REC_EN dffrnq_0/a_311_2787# 0.04302f
C71 dffsnq_0/a_4539_3312# dffrnq_0/a_415_2738# 0
C72 TREAT_EN m2_n2888_1381# 0.76438f
C73 dffsnq_0/a_6267_3356# RSTn 0.00141f
C74 m2_n2888_1381# mux21_0/a_n2807_3163# 0.06446f
C75 m1_n1940_2465# m2_n2888_1381# 0.0018f
C76 TREAT_EN m2_n1118_2715# 0.08524f
C77 dffrnq_0/a_1772_2427# m2_n2888_1381# 0.00389f
C78 m2_n1268_1517# dffsnq_0/a_3222_3356# 0.17173f
C79 m2_n1118_2715# mux21_0/a_n2807_3163# 0
C80 m1_n1940_2465# m2_n1118_2715# 0.00596f
C81 dffrnq_0/a_107_2787# m2_n2888_1381# 0.00276f
C82 dffsnq_0/a_4539_3312# REC_EN 0.00381f
C83 dffsnq_0/a_3222_3356# MODE 0
C84 dffsnq_0/a_5635_3360# RSTn 0.01481f
C85 VDD RSTn 0.01788f
C86 dffrnq_0/a_107_2787# m2_n1118_2715# 0.00379f
C87 dffsnq_0/a_4470_3360# REC_EN 0
C88 dffsnq_0/a_4226_2960# CLK 0
C89 VDD dffrnq_0/a_415_2738# 0
C90 REC_EN dffsnq_0/a_6267_3356# 0
C91 REC_EN nor2_2_0/a_n3725_1897# 0.00736f
C92 CLK dffrnq_0/a_n97_2787# 0
C93 REC_EN VDD 1.02684f
C94 dffsnq_0/a_5635_3360# REC_EN 0.00185f
C95 dffsnq_0/a_4539_3312# dffrnq_0/a_107_2787# 0
C96 TREAT_EN nor2_2_0/a_n3725_1897# 0.00212f
C97 m2_n1268_1517# dffsnq_0/a_3634_2943# 0.04806f
C98 mux21_0/a_n2339_2762# CLK 0
C99 dffsnq_0/a_3222_3356# dffrnq_0/a_n857_2466# 0.02445f
C100 dffrnq_0/a_1667_2471# RSTn 0.00326f
C101 dffrnq_0/a_n445_2787# RSTn 0.00218f
C102 VDD TREAT_EN 0.13379f
C103 m2_n2888_1381# nor2_1_0/a_n4929_4170# 0
C104 VDD mux21_0/a_n2807_3163# 0.00651f
C105 m1_n1940_2465# VDD 0.10995f
C106 dffsnq_0/a_3634_2943# dffsnq_0/a_4022_2960# -0
C107 dffrnq_0/a_1772_2427# VDD -0.00474f
C108 dffrnq_0/a_563_2471# m2_n2888_1381# 0
C109 VDD dffrnq_0/a_107_2787# 0
C110 m2_n1268_1517# dffsnq_0/a_4226_2960# 0.00325f
C111 dffsnq_0/a_3222_3356# RSTn 0.0017f
C112 REC_EN dffrnq_0/a_1667_2471# 0.01442f
C113 REC_EN dffrnq_0/a_n445_2787# 0.08524f
C114 dffsnq_0/a_3222_3356# dffrnq_0/a_415_2738# 0
C115 dffsnq_0/a_3634_2943# dffrnq_0/a_n857_2466# 0.00688f
C116 m2_n1118_2715# m2_n2888_1381# 0.01213f
C117 RSTn dffrnq_0/a_1355_2471# 0.00379f
C118 dffsnq_0/a_6315_3300# RSTn 0.04409f
C119 dffrnq_0/a_311_2787# m2_n2888_1381# 0
C120 mux21_0/a_n2339_2762# m2_n1268_1517# 0
C121 m2_n1118_2715# dffrnq_0/a_311_2787# 0.00134f
C122 REC_EN dffsnq_0/a_3222_3356# 0.00337f
C123 TREAT_EN dffrnq_0/a_n445_2787# 0
C124 mux21_0/a_n2339_2762# MODE 0.03694f
C125 m2_n1268_1517# CLK 0.15857f
C126 CLK MODE 0.04686f
C127 dffsnq_0/a_4226_2960# dffrnq_0/a_n857_2466# 0.00102f
C128 REC_EN dffrnq_0/a_1355_2471# 0.12679f
C129 dffsnq_0/a_4539_3312# m2_n2888_1381# 0.04591f
C130 dffsnq_0/a_3634_2943# RSTn 0.03997f
C131 VDD nor2_1_0/a_n4929_4170# 0
C132 RSTn dffsnq_0/a_4883_3360# 0
C133 dffsnq_0/a_4470_3360# m2_n2888_1381# 0
C134 REC_EN dffsnq_0/a_6315_3300# 0.00366f
C135 dffsnq_0/a_3222_3356# TREAT_EN 0.00124f
C136 dffsnq_0/a_4022_2960# CLK 0
C137 dffsnq_0/a_3634_2943# dffrnq_0/a_415_2738# 0
C138 dffsnq_0/a_3222_3356# mux21_0/a_n2807_3163# 0.00223f
C139 dffsnq_0/a_5411_3360# RSTn 0.054f
C140 m2_n1118_2715# nor2_2_0/a_n3725_1897# 0
C141 dffsnq_0/a_3634_2943# REC_EN 0.00662f
C142 dffsnq_0/a_5635_3360# m2_n2888_1381# 0.03634f
C143 VDD m2_n2888_1381# 0.97305f
C144 dffsnq_0/a_4226_2960# RSTn 0.00118f
C145 REC_EN dffsnq_0/a_4883_3360# 0
C146 VDD m2_n1118_2715# 0.07996f
C147 CLK dffrnq_0/a_n857_2466# 0.01924f
C148 dffrnq_0/a_1772_2427# dffsnq_0/a_6315_3300# 0.00394f
C149 dffsnq_0/a_4226_2960# dffrnq_0/a_415_2738# 0.00357f
C150 REC_EN dffsnq_0/a_5411_3360# 0.00463f
C151 dffsnq_0/a_3634_2943# TREAT_EN 0
C152 m2_n1268_1517# MODE 0.00203f
C153 REC_EN dffsnq_0/a_4226_2960# 0.00294f
C154 dffsnq_0/a_4539_3312# VDD -0
C155 m2_n1268_1517# dffsnq_0/a_4022_2960# 0.00534f
C156 dffrnq_0/a_395_2471# CLK 0
C157 dffrnq_0/a_1772_2427# dffsnq_0/a_5411_3360# 0
C158 dffrnq_0/a_2148_2471# RSTn 0
C159 CLK dffrnq_0/a_415_2738# 0
C160 dffrnq_0/a_1667_2471# m2_n2888_1381# 0
C161 dffrnq_0/a_n445_2787# m2_n2888_1381# 0.0061f
C162 REC_EN dffrnq_0/a_n97_2787# 0.0092f
C163 dffsnq_0/a_4226_2960# TREAT_EN 0
C164 VDD nor2_2_0/a_n3725_1897# 0
C165 dffrnq_0/a_n445_2787# m2_n1118_2715# 0.05126f
C166 mux21_0/a_n2339_2762# REC_EN 0.08079f
C167 dffsnq_0/a_4226_2960# dffrnq_0/a_107_2787# 0
C168 m2_n1268_1517# dffrnq_0/a_n857_2466# 0.00201f
C169 dffsnq_0/a_5635_3360# VDD -0
C170 REC_EN CLK 0.0199f
C171 REC_EN dffrnq_0/a_2148_2471# 0
C172 dffrnq_0/a_n857_2466# MODE 0
C173 dffsnq_0/a_3222_3356# m2_n2888_1381# 0.1587f
C174 TREAT_EN dffrnq_0/a_n97_2787# 0
C175 dffsnq_0/a_3222_3356# m2_n1118_2715# 0.00251f
C176 mux21_0/a_n2394_2806# TREAT_EN 0
C177 mux21_0/a_n2339_2762# TREAT_EN 0.07597f
C178 dffrnq_0/a_1355_2471# m2_n2888_1381# 0.00331f
C179 mux21_0/a_n2339_2762# mux21_0/a_n2807_3163# -0.00283f
C180 mux21_0/a_n2339_2762# m1_n1940_2465# 0
C181 dffsnq_0/a_4539_3312# dffrnq_0/a_n445_2787# 0.00273f
C182 m2_n1268_1517# dffsnq_0/a_4479_2960# 0
C183 TREAT_EN CLK 0.09284f
C184 CLK mux21_0/a_n2807_3163# 0.02062f
C185 dffsnq_0/a_6315_3300# m2_n2888_1381# 0.05467f
C186 m1_n1940_2465# CLK 0.00795f
C187 m2_n1268_1517# RSTn 0
C188 CLK dffrnq_0/a_107_2787# 0
C189 VDD dffrnq_0/a_n445_2787# 0
C190 dffsnq_0/a_3634_2943# m2_n2888_1381# 0.08736f
C191 m2_n2888_1381# dffsnq_0/a_4883_3360# 0
C192 dffsnq_0/a_3634_2943# m2_n1118_2715# 0
C193 m2_n1268_1517# REC_EN 0
C194 dffsnq_0/a_5411_3360# m2_n2888_1381# 0.03285f
C195 TREAT_EN mux21_0/a_n2035_2806# 0
C196 REC_EN MODE 0.13488f
C197 dffsnq_0/a_3222_3356# VDD 0.00338f
C198 dffsnq_0/a_4226_2960# m2_n2888_1381# 0.02954f
C199 dffsnq_0/a_4022_2960# REC_EN 0
C200 dffrnq_0/a_n857_2466# RSTn 0.00121f
C201 CLK mux21_0/a_n2427_3346# 0
C202 m2_n1268_1517# TREAT_EN 0.01613f
C203 VDD dffrnq_0/a_1355_2471# 0.00105f
C204 m2_n1268_1517# mux21_0/a_n2807_3163# 0.00266f
C205 TREAT_EN MODE 0.28553f
C206 MODE mux21_0/a_n2807_3163# 0.09448f
C207 dffsnq_0/a_5635_3360# dffsnq_0/a_6315_3300# -0
C208 dffsnq_0/a_6315_3300# VDD 0.00615f
C209 m1_n1940_2465# MODE 0.03848f
C210 dffsnq_0/a_4226_2960# dffrnq_0/a_311_2787# 0
C211 dffrnq_0/a_n97_2787# m2_n2888_1381# 0
C212 dffsnq_0/a_4022_2960# TREAT_EN 0
C213 m2_n1118_2715# dffrnq_0/a_n97_2787# 0.00551f
C214 REC_EN dffrnq_0/a_n857_2466# 0.0471f
C215 mux21_0/a_n2394_2806# m2_n2888_1381# 0.00103f
C216 mux21_0/a_n2339_2762# m2_n2888_1381# 0.03841f
C217 dffrnq_0/a_395_2471# RSTn 0
C218 dffsnq_0/a_3634_2943# VDD -0
C219 CLK m2_n2888_1381# 0.00687f
C220 m2_n2888_1381# VSS 1.35852f
C221 m2_n1118_2715# VSS 0.32666f
C222 REC_EN VSS 1.5599f
C223 RSTn VSS 2.34515f
C224 MODE VSS 1.15652f
C225 m1_n1940_2465# VSS 0.49336f
C226 TREAT_EN VSS 0.89223f
C227 nor2_1_0/a_n4929_4170# VSS -0
C228 VDD VSS 22.23366f
C229 dffrnq_0/a_1667_2471# VSS 0.01697f
C230 dffrnq_0/a_1772_2427# VSS 0.62774f
C231 dffrnq_0/a_1355_2471# VSS 0.37514f
C232 dffrnq_0/a_311_2787# VSS 0.01297f
C233 dffrnq_0/a_107_2787# VSS 0.29173f
C234 dffrnq_0/a_n97_2787# VSS 0.02321f
C235 dffrnq_0/a_415_2738# VSS 0.28147f
C236 dffrnq_0/a_n445_2787# VSS 0.68798f
C237 dffrnq_0/a_n857_2466# VSS 1.46629f
C238 CLK VSS 0.86461f
C239 mux21_0/a_n2339_2762# VSS 0.46031f
C240 mux21_0/a_n2807_3163# VSS 0.32921f
C241 m2_n1268_1517# VSS 0.34757f
C242 dffsnq_0/a_6315_3300# VSS 0.58924f
C243 dffsnq_0/a_5635_3360# VSS 0.04999f
C244 dffsnq_0/a_5411_3360# VSS 0.43599f
C245 dffsnq_0/a_4022_2960# VSS 0.01977f
C246 dffsnq_0/a_4226_2960# VSS 0.3038f
C247 dffsnq_0/a_4539_3312# VSS 0.28789f
C248 dffsnq_0/a_3634_2943# VSS 1.22248f
C249 dffsnq_0/a_3222_3356# VSS 1.32709f
.ends
