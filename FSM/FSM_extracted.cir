* Extracted by KLayout with GF180MCU LVS runset on : 11/08/2026 02:36

.SUBCKT FSM VDD RN|SETN Q|S0 D|Z I1|TREAT_EN M|S I0|Q|REC_EN CLK VSS Mb D
+ gf180mcu_gnd
M$1 VDD M|S \$4 VDD pfet_05v0 L=0.5U W=0.615U AS=0.2706P AD=0.1599P PS=2.11U
+ PD=1.135U
M$2 \$14 I0|Q|REC_EN VDD VDD pfet_05v0 L=0.5U W=0.615U AS=0.1599P AD=0.0738P
+ PS=1.135U PD=0.855U
M$3 \$5 M|S \$14 VDD pfet_05v0 L=0.5U W=0.615U AS=0.0738P AD=0.1599P PS=0.855U
+ PD=1.135U
M$4 \$13 \$4 \$5 VDD pfet_05v0 L=0.5U W=0.615U AS=0.1599P AD=0.0845625P
+ PS=1.135U PD=0.89U
M$5 VDD I1|TREAT_EN \$13 VDD pfet_05v0 L=0.5U W=0.615U AS=0.0845625P
+ AD=0.4298375P PS=0.89U PD=2.185U
M$6 D|Z \$5 VDD VDD pfet_05v0 L=0.5U W=1.22U AS=0.4298375P AD=0.5368P PS=2.185U
+ PD=3.32U
M$7 \$9 D|Z VDD VDD pfet_05v0 L=0.5U W=0.505U AS=0.22725P AD=0.1313P PS=1.91U
+ PD=1.025U
M$8 \$10 \$8 \$9 VDD pfet_05v0 L=0.5U W=0.505U AS=0.1313P AD=0.1931625P
+ PS=1.025U PD=1.27U
M$9 \$28 \$7 \$10 VDD pfet_05v0 L=0.5U W=0.505U AS=0.1931625P AD=0.101P
+ PS=1.27U PD=0.905U
M$10 \$28 \$11 VDD VDD pfet_05v0 L=0.5U W=0.505U AS=0.3975P AD=0.101P PS=2.185U
+ PD=0.905U
M$11 \$11 \$10 VDD VDD pfet_05v0 L=0.5U W=0.585U AS=0.3975P AD=0.1521P
+ PS=2.185U PD=1.105U
M$12 \$11 RN|SETN VDD VDD pfet_05v0 L=0.5U W=0.585U AS=0.4149P AD=0.1521P
+ PS=2.65U PD=1.105U
M$13 \$20 RN|SETN VDD VDD pfet_05v0 L=0.5U W=0.78U AS=0.3432P AD=0.2028P
+ PS=2.44U PD=1.3U
M$14 VDD \$12 \$20 VDD pfet_05v0 L=0.5U W=0.78U AS=0.2028P AD=0.3276P PS=1.3U
+ PD=1.62U
M$15 \$12 \$19 VDD VDD pfet_05v0 L=0.5U W=0.78U AS=0.3276P AD=0.3432P PS=1.62U
+ PD=2.44U
M$16 \$19 \$7 \$11 VDD pfet_05v0 L=0.5U W=0.415U AS=0.27805P AD=0.1079P
+ PS=2.17U PD=0.935U
M$17 \$20 \$8 \$19 VDD pfet_05v0 L=0.5U W=0.415U AS=0.1079P AD=0.1826P
+ PS=0.935U PD=1.71U
M$18 VDD CLK \$7 VDD pfet_05v0 L=0.5U W=0.865U AS=0.3806P AD=0.2249P PS=2.61U
+ PD=1.385U
M$19 \$8 \$7 VDD VDD pfet_05v0 L=0.5U W=0.865U AS=0.2249P AD=0.3806P PS=1.385U
+ PD=2.61U
M$20 Q|S0 \$12 VDD VDD pfet_05v0 L=0.5U W=1.215U AS=0.5346P AD=0.6561P PS=3.31U
+ PD=3.51U
M$21 \$49 D VDD VDD pfet_05v0 L=0.5U W=0.78U AS=0.3432P AD=0.2028P PS=2.44U
+ PD=1.3U
M$22 \$52 \$51 \$49 VDD pfet_05v0 L=0.5U W=0.78U AS=0.2028P AD=0.2028P PS=1.3U
+ PD=1.3U
M$23 \$67 \$48 \$52 VDD pfet_05v0 L=0.5U W=0.78U AS=0.2028P AD=0.2028P PS=1.3U
+ PD=1.3U
M$24 VDD \$53 \$67 VDD pfet_05v0 L=0.5U W=0.78U AS=0.2028P AD=0.45P PS=1.3U
+ PD=2.02U
M$25 \$67 RN|SETN VDD VDD pfet_05v0 L=0.5U W=0.78U AS=0.45P AD=0.3432P PS=2.02U
+ PD=2.44U
M$26 \$53 \$52 VDD VDD pfet_05v0 L=0.5U W=0.505U AS=0.2222P AD=0.2424P PS=1.89U
+ PD=1.465U
M$27 \$54 \$48 \$53 VDD pfet_05v0 L=0.5U W=0.505U AS=0.2424P AD=0.2537625P
+ PS=1.465U PD=1.51U
M$28 \$55 \$51 \$54 VDD pfet_05v0 L=0.5U W=0.505U AS=0.2537625P AD=0.1313P
+ PS=1.51U PD=1.025U
M$29 \$55 \$56 VDD VDD pfet_05v0 L=0.5U W=0.505U AS=0.29465P AD=0.1313P
+ PS=1.74U PD=1.025U
M$30 \$56 RN|SETN VDD VDD pfet_05v0 L=0.5U W=1U AS=0.29465P AD=0.26P PS=1.74U
+ PD=1.52U
M$31 VDD \$54 \$56 VDD pfet_05v0 L=0.5U W=1U AS=0.26P AD=0.44P PS=1.52U PD=2.88U
M$32 VDD CLK \$48 VDD pfet_05v0 L=0.5U W=0.865U AS=0.3806P AD=0.2249P PS=2.61U
+ PD=1.385U
M$33 \$51 \$48 VDD VDD pfet_05v0 L=0.5U W=0.865U AS=0.2249P AD=0.3806P
+ PS=1.385U PD=2.61U
M$34 I0|Q|REC_EN \$56 VDD VDD pfet_05v0 L=0.5U W=1.215U AS=0.5346P AD=0.5346P
+ PS=3.31U PD=3.31U
M$35 \$69 Q|S0 VDD VDD pfet_05v0 L=0.5U W=1.22U AS=0.5368P AD=0.4087P PS=3.32U
+ PD=1.89U
M$36 I1|TREAT_EN I0|Q|REC_EN \$69 VDD pfet_05v0 L=0.5U W=1.22U AS=0.4087P
+ AD=0.5368P PS=1.89U PD=3.32U
M$37 Mb M|S VDD VDD pfet_05v0 L=0.5U W=1.22U AS=0.5368P AD=0.5368P PS=3.32U
+ PD=3.32U
M$38 \$72 Mb VDD VDD pfet_05v0 L=0.5U W=1.22U AS=0.5368P AD=0.4087P PS=3.32U
+ PD=1.89U
M$39 D I1|TREAT_EN \$72 VDD pfet_05v0 L=0.5U W=1.22U AS=0.4087P AD=0.5368P
+ PS=1.89U PD=3.32U
M$40 \$9 D|Z VSS gf180mcu_gnd nfet_05v0 L=0.6U W=0.36U AS=0.1584P AD=0.0936P
+ PS=1.6U PD=0.88U
M$41 \$10 \$7 \$9 gf180mcu_gnd nfet_05v0 L=0.6U W=0.36U AS=0.0936P AD=0.0936P
+ PS=0.88U PD=0.88U
M$42 \$46 \$8 \$10 gf180mcu_gnd nfet_05v0 L=0.6U W=0.36U AS=0.0936P AD=0.0621P
+ PS=0.88U PD=0.705U
M$43 VSS \$11 \$46 gf180mcu_gnd nfet_05v0 L=0.6U W=0.36U AS=0.0621P AD=0.0936P
+ PS=0.705U PD=0.88U
M$44 \$44 \$10 VSS gf180mcu_gnd nfet_05v0 L=0.6U W=0.36U AS=0.0936P AD=0.0864P
+ PS=0.88U PD=0.84U
M$45 \$44 RN|SETN \$11 gf180mcu_gnd nfet_05v0 L=0.6U W=0.36U AS=0.1989P
+ AD=0.0864P PS=1.465U PD=0.84U
M$46 \$19 \$8 \$11 gf180mcu_gnd nfet_05v0 L=0.6U W=0.36U AS=0.1989P AD=0.0936P
+ PS=1.465U PD=0.88U
M$47 \$19 \$7 \$20 gf180mcu_gnd nfet_05v0 L=0.6U W=0.36U AS=0.2898P AD=0.0936P
+ PS=2.33U PD=0.88U
M$48 VSS CLK \$7 gf180mcu_gnd nfet_05v0 L=0.6U W=0.405U AS=0.1782P AD=0.1053P
+ PS=1.69U PD=0.925U
M$49 \$8 \$7 VSS gf180mcu_gnd nfet_05v0 L=0.6U W=0.405U AS=0.1053P AD=0.1782P
+ PS=0.925U PD=1.69U
M$50 \$40 RN|SETN \$20 gf180mcu_gnd nfet_05v0 L=0.6U W=0.405U AS=0.3123P
+ AD=0.0486P PS=2.38U PD=0.645U
M$51 VSS \$12 \$40 gf180mcu_gnd nfet_05v0 L=0.6U W=0.405U AS=0.0486P
+ AD=0.14985P PS=0.645U PD=1.145U
M$52 \$12 \$19 VSS gf180mcu_gnd nfet_05v0 L=0.6U W=0.405U AS=0.14985P
+ AD=0.1782P PS=1.145U PD=1.69U
M$53 VSS M|S \$4 gf180mcu_gnd nfet_05v0 L=0.6U W=0.36U AS=0.1584P AD=0.0936P
+ PS=1.6U PD=0.88U
M$54 \$42 I0|Q|REC_EN VSS gf180mcu_gnd nfet_05v0 L=0.6U W=0.36U AS=0.0936P
+ AD=0.0432P PS=0.88U PD=0.6U
M$55 \$5 \$4 \$42 gf180mcu_gnd nfet_05v0 L=0.6U W=0.36U AS=0.0432P AD=0.0936P
+ PS=0.6U PD=0.88U
M$56 \$43 M|S \$5 gf180mcu_gnd nfet_05v0 L=0.6U W=0.36U AS=0.0936P AD=0.0432P
+ PS=0.88U PD=0.6U
M$57 \$43 I1|TREAT_EN VSS gf180mcu_gnd nfet_05v0 L=0.6U W=0.36U AS=0.218P
+ AD=0.0432P PS=1.52U PD=0.6U
M$58 D|Z \$5 VSS gf180mcu_gnd nfet_05v0 L=0.6U W=0.82U AS=0.218P AD=0.3608P
+ PS=1.52U PD=2.52U
M$59 Q|S0 \$12 VSS gf180mcu_gnd nfet_05v0 L=0.6U W=0.815U AS=0.3586P AD=0.3586P
+ PS=2.51U PD=2.51U
M$60 I1|TREAT_EN Q|S0 VSS gf180mcu_gnd nfet_05v0 L=0.6U W=0.565U AS=0.2486P
+ AD=0.1469P PS=2.01U PD=1.085U
M$61 VSS I0|Q|REC_EN I1|TREAT_EN gf180mcu_gnd nfet_05v0 L=0.6U W=0.565U
+ AS=0.1469P AD=0.2486P PS=1.085U PD=2.01U
M$62 D Mb VSS gf180mcu_gnd nfet_05v0 L=0.6U W=0.565U AS=0.2486P AD=0.1469P
+ PS=2.01U PD=1.085U
M$63 VSS I1|TREAT_EN D gf180mcu_gnd nfet_05v0 L=0.6U W=0.565U AS=0.1469P
+ AD=0.2486P PS=1.085U PD=2.01U
M$64 \$49 D VSS gf180mcu_gnd nfet_05v0 L=0.6U W=0.36U AS=0.1584P AD=0.0936P
+ PS=1.6U PD=0.88U
M$65 \$52 \$48 \$49 gf180mcu_gnd nfet_05v0 L=0.6U W=0.36U AS=0.0936P AD=0.0936P
+ PS=0.88U PD=0.88U
M$66 \$66 \$51 \$52 gf180mcu_gnd nfet_05v0 L=0.6U W=0.36U AS=0.0936P AD=0.0432P
+ PS=0.88U PD=0.6U
M$67 \$65 \$53 \$66 gf180mcu_gnd nfet_05v0 L=0.6U W=0.36U AS=0.0432P AD=0.0432P
+ PS=0.6U PD=0.6U
M$68 \$65 RN|SETN VSS gf180mcu_gnd nfet_05v0 L=0.6U W=0.36U AS=0.2016P
+ AD=0.0432P PS=1.48U PD=0.6U
M$69 \$53 \$52 VSS gf180mcu_gnd nfet_05v0 L=0.6U W=0.36U AS=0.2016P AD=0.2007P
+ PS=1.48U PD=1.475U
M$70 \$54 \$51 \$53 gf180mcu_gnd nfet_05v0 L=0.6U W=0.36U AS=0.2007P AD=0.2007P
+ PS=1.475U PD=1.475U
M$71 \$55 \$48 \$54 gf180mcu_gnd nfet_05v0 L=0.6U W=0.36U AS=0.2007P AD=0.0945P
+ PS=1.475U PD=0.885U
M$72 VSS \$56 \$55 gf180mcu_gnd nfet_05v0 L=0.6U W=0.36U AS=0.0945P AD=0.1224P
+ PS=0.885U PD=1.04U
M$73 VSS RN|SETN \$61 gf180mcu_gnd nfet_05v0 L=0.6U W=0.36U AS=0.134P
+ AD=0.1224P PS=1.1U PD=1.04U
M$74 \$56 \$54 \$61 gf180mcu_gnd nfet_05v0 L=0.6U W=0.4U AS=0.134P AD=0.176P
+ PS=1.1U PD=1.68U
M$75 Mb M|S VSS gf180mcu_gnd nfet_05v0 L=0.6U W=0.82U AS=0.3608P AD=0.3608P
+ PS=2.52U PD=2.52U
M$76 VSS CLK \$48 gf180mcu_gnd nfet_05v0 L=0.6U W=0.405U AS=0.1782P AD=0.1053P
+ PS=1.69U PD=0.925U
M$77 \$51 \$48 VSS gf180mcu_gnd nfet_05v0 L=0.6U W=0.405U AS=0.1053P AD=0.1782P
+ PS=0.925U PD=1.69U
M$78 I0|Q|REC_EN \$56 VSS gf180mcu_gnd nfet_05v0 L=0.6U W=0.815U AS=0.3586P
+ AD=0.3586P PS=2.51U PD=2.51U
.ENDS FSM
