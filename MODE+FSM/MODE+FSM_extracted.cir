* Extracted by KLayout with GF180MCU LVS runset on : 01/09/2026 01:47

.SUBCKT MODE+FSM VDD TREAT_EN REC_EN|S1 A2|S0 MODE_Q2 CLK RN|SETN VSS MODE_Q
+ MODE
M$1 \$21 REC_EN|S1 VDD VDD pfet_05v0 L=0.5U W=1.22U AS=0.5368P AD=0.4087P
+ PS=3.32U PD=1.89U
M$2 TREAT_EN A2|S0 \$21 VDD pfet_05v0 L=0.5U W=1.22U AS=0.4087P AD=0.5368P
+ PS=1.89U PD=3.32U
M$3 \$4 A2|S0 VDD VDD pfet_05v0 L=0.5U W=0.6U AS=0.264P AD=0.156P PS=2.08U
+ PD=1.12U
M$4 VDD MODE_Q2 \$4 VDD pfet_05v0 L=0.5U W=0.6U AS=0.156P AD=0.40575P PS=1.12U
+ PD=2.055U
M$5 \$5 \$4 VDD VDD pfet_05v0 L=0.5U W=1.215U AS=0.40575P AD=0.5346P PS=2.055U
+ PD=3.31U
M$6 REC_EN|S1 \$18 VDD VDD pfet_05v0 L=0.5U W=1.215U AS=0.5346P AD=0.637875P
+ PS=3.31U PD=3.48U
M$7 VDD CLK \$6 VDD pfet_05v0 L=0.5U W=0.865U AS=0.3806P AD=0.2249P PS=2.61U
+ PD=1.385U
M$8 \$7 \$6 VDD VDD pfet_05v0 L=0.5U W=0.865U AS=0.2249P AD=0.3806P PS=1.385U
+ PD=2.61U
M$9 \$13 \$5 VDD VDD pfet_05v0 L=0.5U W=0.78U AS=0.3432P AD=0.2028P PS=2.44U
+ PD=1.3U
M$10 \$14 \$7 \$13 VDD pfet_05v0 L=0.5U W=0.78U AS=0.2028P AD=0.2028P PS=1.3U
+ PD=1.3U
M$11 \$15 \$6 \$14 VDD pfet_05v0 L=0.5U W=0.78U AS=0.2028P AD=0.2028P PS=1.3U
+ PD=1.3U
M$12 \$15 \$16 VDD VDD pfet_05v0 L=0.5U W=0.78U AS=0.45P AD=0.2028P PS=2.02U
+ PD=1.3U
M$13 \$15 RN|SETN VDD VDD pfet_05v0 L=0.5U W=0.78U AS=0.45P AD=0.3432P PS=2.02U
+ PD=2.44U
M$14 \$16 \$14 VDD VDD pfet_05v0 L=0.5U W=0.505U AS=0.2222P AD=0.2424P PS=1.89U
+ PD=1.465U
M$15 \$8 \$6 \$16 VDD pfet_05v0 L=0.5U W=0.505U AS=0.2424P AD=0.2537625P
+ PS=1.465U PD=1.51U
M$16 \$17 \$7 \$8 VDD pfet_05v0 L=0.5U W=0.505U AS=0.2537625P AD=0.1313P
+ PS=1.51U PD=1.025U
M$17 \$17 \$18 VDD VDD pfet_05v0 L=0.5U W=0.505U AS=0.29465P AD=0.1313P
+ PS=1.74U PD=1.025U
M$18 \$18 RN|SETN VDD VDD pfet_05v0 L=0.5U W=1U AS=0.29465P AD=0.26P PS=1.74U
+ PD=1.52U
M$19 VDD \$8 \$18 VDD pfet_05v0 L=0.5U W=1U AS=0.26P AD=0.44P PS=1.52U PD=2.88U
M$20 \$68 REC_EN|S1 \$32 VDD pfet_05v0 L=0.5U W=0.565U AS=0.2486P AD=0.1469P
+ PS=2.01U PD=1.085U
M$21 \$68 MODE_Q2 VDD VDD pfet_05v0 L=0.5U W=0.565U AS=0.38705P AD=0.1469P
+ PS=2.08U PD=1.085U
M$22 \$33 \$32 VDD VDD pfet_05v0 L=0.5U W=1.22U AS=0.38705P AD=0.5368P PS=2.08U
+ PD=3.32U
M$23 VDD CLK \$47 VDD pfet_05v0 L=0.5U W=0.865U AS=0.3806P AD=0.2249P PS=2.61U
+ PD=1.385U
M$24 \$49 \$47 VDD VDD pfet_05v0 L=0.5U W=0.865U AS=0.2249P AD=0.3806P
+ PS=1.385U PD=2.61U
M$25 \$34 \$33 VDD VDD pfet_05v0 L=0.5U W=0.505U AS=0.22725P AD=0.1313P
+ PS=1.91U PD=1.025U
M$26 \$35 \$49 \$34 VDD pfet_05v0 L=0.5U W=0.505U AS=0.1313P AD=0.1931625P
+ PS=1.025U PD=1.27U
M$27 \$73 \$47 \$35 VDD pfet_05v0 L=0.5U W=0.505U AS=0.1931625P AD=0.101P
+ PS=1.27U PD=0.905U
M$28 VDD \$50 \$73 VDD pfet_05v0 L=0.5U W=0.505U AS=0.101P AD=0.3975P PS=0.905U
+ PD=2.185U
M$29 \$50 \$35 VDD VDD pfet_05v0 L=0.5U W=0.585U AS=0.3975P AD=0.1521P
+ PS=2.185U PD=1.105U
M$30 VDD RN|SETN \$50 VDD pfet_05v0 L=0.5U W=0.585U AS=0.1521P AD=0.4149P
+ PS=1.105U PD=2.65U
M$31 \$36 \$47 \$50 VDD pfet_05v0 L=0.5U W=0.415U AS=0.27805P AD=0.1079P
+ PS=2.17U PD=0.935U
M$32 \$51 \$49 \$36 VDD pfet_05v0 L=0.5U W=0.415U AS=0.1079P AD=0.1826P
+ PS=0.935U PD=1.71U
M$33 \$51 RN|SETN VDD VDD pfet_05v0 L=0.5U W=0.78U AS=0.3432P AD=0.2028P
+ PS=2.44U PD=1.3U
M$34 VDD \$52 \$51 VDD pfet_05v0 L=0.5U W=0.78U AS=0.2028P AD=0.3276P PS=1.3U
+ PD=1.62U
M$35 \$52 \$36 VDD VDD pfet_05v0 L=0.5U W=0.78U AS=0.3276P AD=0.3432P PS=1.62U
+ PD=2.44U
M$36 A2|S0 \$52 VDD VDD pfet_05v0 L=0.5U W=1.215U AS=0.5346P AD=0.6561P
+ PS=3.31U PD=3.51U
M$37 VDD CLK \$63 VDD pfet_05v0 L=0.5U W=0.865U AS=0.3806P AD=0.2249P PS=2.61U
+ PD=1.385U
M$38 \$64 \$63 VDD VDD pfet_05v0 L=0.5U W=0.865U AS=0.2249P AD=0.3806P
+ PS=1.385U PD=2.61U
M$39 MODE_Q2 \$83 VDD VDD pfet_05v0 L=0.5U W=1.215U AS=0.5346P AD=0.5346P
+ PS=3.31U PD=3.31U
M$40 \$77 MODE_Q VDD VDD pfet_05v0 L=0.5U W=0.78U AS=0.3432P AD=0.2028P
+ PS=2.44U PD=1.3U
M$41 \$78 \$64 \$77 VDD pfet_05v0 L=0.5U W=0.78U AS=0.2028P AD=0.2028P PS=1.3U
+ PD=1.3U
M$42 \$79 \$63 \$78 VDD pfet_05v0 L=0.5U W=0.78U AS=0.2028P AD=0.2028P PS=1.3U
+ PD=1.3U
M$43 \$79 \$80 VDD VDD pfet_05v0 L=0.5U W=0.78U AS=0.45P AD=0.2028P PS=2.02U
+ PD=1.3U
M$44 \$79 RN|SETN VDD VDD pfet_05v0 L=0.5U W=0.78U AS=0.45P AD=0.3432P PS=2.02U
+ PD=2.44U
M$45 \$80 \$78 VDD VDD pfet_05v0 L=0.5U W=0.505U AS=0.2222P AD=0.2424P PS=1.89U
+ PD=1.465U
M$46 \$66 \$63 \$80 VDD pfet_05v0 L=0.5U W=0.505U AS=0.2424P AD=0.2537625P
+ PS=1.465U PD=1.51U
M$47 \$82 \$64 \$66 VDD pfet_05v0 L=0.5U W=0.505U AS=0.2537625P AD=0.1313P
+ PS=1.51U PD=1.025U
M$48 \$82 \$83 VDD VDD pfet_05v0 L=0.5U W=0.505U AS=0.29465P AD=0.1313P
+ PS=1.74U PD=1.025U
M$49 \$83 RN|SETN VDD VDD pfet_05v0 L=0.5U W=1U AS=0.29465P AD=0.26P PS=1.74U
+ PD=1.52U
M$50 VDD \$66 \$83 VDD pfet_05v0 L=0.5U W=1U AS=0.26P AD=0.44P PS=1.52U PD=2.88U
M$51 VDD CLK \$99 VDD pfet_05v0 L=0.5U W=0.865U AS=0.3806P AD=0.2249P PS=2.61U
+ PD=1.385U
M$52 \$103 \$99 VDD VDD pfet_05v0 L=0.5U W=0.865U AS=0.2249P AD=0.3806P
+ PS=1.385U PD=2.61U
M$53 \$101 MODE VDD VDD pfet_05v0 L=0.5U W=0.78U AS=0.3432P AD=0.2028P PS=2.44U
+ PD=1.3U
M$54 \$104 \$103 \$101 VDD pfet_05v0 L=0.5U W=0.78U AS=0.2028P AD=0.2028P
+ PS=1.3U PD=1.3U
M$55 \$116 \$99 \$104 VDD pfet_05v0 L=0.5U W=0.78U AS=0.2028P AD=0.2028P
+ PS=1.3U PD=1.3U
M$56 VDD \$105 \$116 VDD pfet_05v0 L=0.5U W=0.78U AS=0.2028P AD=0.45P PS=1.3U
+ PD=2.02U
M$57 \$116 RN|SETN VDD VDD pfet_05v0 L=0.5U W=0.78U AS=0.45P AD=0.3432P
+ PS=2.02U PD=2.44U
M$58 \$105 \$104 VDD VDD pfet_05v0 L=0.5U W=0.505U AS=0.2222P AD=0.2424P
+ PS=1.89U PD=1.465U
M$59 \$106 \$99 \$105 VDD pfet_05v0 L=0.5U W=0.505U AS=0.2424P AD=0.2537625P
+ PS=1.465U PD=1.51U
M$60 \$107 \$103 \$106 VDD pfet_05v0 L=0.5U W=0.505U AS=0.2537625P AD=0.1313P
+ PS=1.51U PD=1.025U
M$61 \$107 \$108 VDD VDD pfet_05v0 L=0.5U W=0.505U AS=0.29465P AD=0.1313P
+ PS=1.74U PD=1.025U
M$62 \$108 RN|SETN VDD VDD pfet_05v0 L=0.5U W=1U AS=0.29465P AD=0.26P PS=1.74U
+ PD=1.52U
M$63 VDD \$106 \$108 VDD pfet_05v0 L=0.5U W=1U AS=0.26P AD=0.44P PS=1.52U
+ PD=2.88U
M$64 MODE_Q \$108 VDD VDD pfet_05v0 L=0.5U W=1.215U AS=0.5346P AD=0.5346P
+ PS=3.31U PD=3.31U
M$65 \$40 A2|S0 \$4 VSS nfet_05v0 L=0.6U W=0.365U AS=0.1606P AD=0.0584P
+ PS=1.61U PD=0.685U
M$66 VSS MODE_Q2 \$40 VSS nfet_05v0 L=0.6U W=0.365U AS=0.0584P AD=0.23405P
+ PS=0.685U PD=1.555U
M$67 \$5 \$4 VSS VSS nfet_05v0 L=0.6U W=0.815U AS=0.23405P AD=0.3586P PS=1.555U
+ PD=2.51U
M$68 VSS CLK \$6 VSS nfet_05v0 L=0.6U W=0.405U AS=0.1782P AD=0.1053P PS=1.69U
+ PD=0.925U
M$69 \$7 \$6 VSS VSS nfet_05v0 L=0.6U W=0.405U AS=0.1053P AD=0.1782P PS=0.925U
+ PD=1.69U
M$70 REC_EN|S1 \$18 VSS VSS nfet_05v0 L=0.6U W=0.815U AS=0.3586P AD=0.427875P
+ PS=2.51U PD=2.68U
M$71 \$13 \$5 VSS VSS nfet_05v0 L=0.6U W=0.36U AS=0.1584P AD=0.0936P PS=1.6U
+ PD=0.88U
M$72 \$14 \$6 \$13 VSS nfet_05v0 L=0.6U W=0.36U AS=0.0936P AD=0.0936P PS=0.88U
+ PD=0.88U
M$73 \$46 \$7 \$14 VSS nfet_05v0 L=0.6U W=0.36U AS=0.0936P AD=0.0432P PS=0.88U
+ PD=0.6U
M$74 \$45 \$16 \$46 VSS nfet_05v0 L=0.6U W=0.36U AS=0.0432P AD=0.0432P PS=0.6U
+ PD=0.6U
M$75 VSS RN|SETN \$45 VSS nfet_05v0 L=0.6U W=0.36U AS=0.0432P AD=0.2016P
+ PS=0.6U PD=1.48U
M$76 VSS \$14 \$16 VSS nfet_05v0 L=0.6U W=0.36U AS=0.2007P AD=0.2016P PS=1.475U
+ PD=1.48U
M$77 \$8 \$7 \$16 VSS nfet_05v0 L=0.6U W=0.36U AS=0.2007P AD=0.2007P PS=1.475U
+ PD=1.475U
M$78 \$17 \$6 \$8 VSS nfet_05v0 L=0.6U W=0.36U AS=0.2007P AD=0.0945P PS=1.475U
+ PD=0.885U
M$79 VSS \$18 \$17 VSS nfet_05v0 L=0.6U W=0.36U AS=0.0945P AD=0.1224P PS=0.885U
+ PD=1.04U
M$80 \$43 RN|SETN VSS VSS nfet_05v0 L=0.6U W=0.36U AS=0.1224P AD=0.134P
+ PS=1.04U PD=1.1U
M$81 \$18 \$8 \$43 VSS nfet_05v0 L=0.6U W=0.4U AS=0.134P AD=0.176P PS=1.1U
+ PD=1.68U
M$82 TREAT_EN REC_EN|S1 VSS VSS nfet_05v0 L=0.6U W=0.565U AS=0.2486P AD=0.1469P
+ PS=2.01U PD=1.085U
M$83 VSS A2|S0 TREAT_EN VSS nfet_05v0 L=0.6U W=0.565U AS=0.1469P AD=0.2486P
+ PS=1.085U PD=2.01U
M$84 \$32 REC_EN|S1 VSS VSS nfet_05v0 L=0.6U W=0.36U AS=0.1584P AD=0.0936P
+ PS=1.6U PD=0.88U
M$85 \$32 MODE_Q2 VSS VSS nfet_05v0 L=0.6U W=0.36U AS=0.2288P AD=0.0936P
+ PS=1.58U PD=0.88U
M$86 \$33 \$32 VSS VSS nfet_05v0 L=0.6U W=0.82U AS=0.2288P AD=0.3608P PS=1.58U
+ PD=2.52U
M$87 VSS CLK \$47 VSS nfet_05v0 L=0.6U W=0.405U AS=0.1782P AD=0.1053P PS=1.69U
+ PD=0.925U
M$88 \$49 \$47 VSS VSS nfet_05v0 L=0.6U W=0.405U AS=0.1053P AD=0.1782P
+ PS=0.925U PD=1.69U
M$89 \$34 \$33 VSS VSS nfet_05v0 L=0.6U W=0.36U AS=0.1584P AD=0.0936P PS=1.6U
+ PD=0.88U
M$90 \$35 \$47 \$34 VSS nfet_05v0 L=0.6U W=0.36U AS=0.0936P AD=0.0936P PS=0.88U
+ PD=0.88U
M$91 \$60 \$49 \$35 VSS nfet_05v0 L=0.6U W=0.36U AS=0.0936P AD=0.0621P PS=0.88U
+ PD=0.705U
M$92 VSS \$50 \$60 VSS nfet_05v0 L=0.6U W=0.36U AS=0.0621P AD=0.0936P PS=0.705U
+ PD=0.88U
M$93 \$61 \$35 VSS VSS nfet_05v0 L=0.6U W=0.36U AS=0.0936P AD=0.0864P PS=0.88U
+ PD=0.84U
M$94 \$50 RN|SETN \$61 VSS nfet_05v0 L=0.6U W=0.36U AS=0.0864P AD=0.1989P
+ PS=0.84U PD=1.465U
M$95 \$36 \$49 \$50 VSS nfet_05v0 L=0.6U W=0.36U AS=0.1989P AD=0.0936P
+ PS=1.465U PD=0.88U
M$96 \$51 \$47 \$36 VSS nfet_05v0 L=0.6U W=0.36U AS=0.0936P AD=0.2898P PS=0.88U
+ PD=2.33U
M$97 \$58 RN|SETN \$51 VSS nfet_05v0 L=0.6U W=0.405U AS=0.3123P AD=0.0486P
+ PS=2.38U PD=0.645U
M$98 VSS \$52 \$58 VSS nfet_05v0 L=0.6U W=0.405U AS=0.0486P AD=0.14985P
+ PS=0.645U PD=1.145U
M$99 \$52 \$36 VSS VSS nfet_05v0 L=0.6U W=0.405U AS=0.14985P AD=0.1782P
+ PS=1.145U PD=1.69U
M$100 A2|S0 \$52 VSS VSS nfet_05v0 L=0.6U W=0.815U AS=0.3586P AD=0.3586P
+ PS=2.51U PD=2.51U
M$101 VSS CLK \$99 VSS nfet_05v0 L=0.6U W=0.405U AS=0.1782P AD=0.1053P PS=1.69U
+ PD=0.925U
M$102 \$103 \$99 VSS VSS nfet_05v0 L=0.6U W=0.405U AS=0.1053P AD=0.1782P
+ PS=0.925U PD=1.69U
M$103 VSS CLK \$63 VSS nfet_05v0 L=0.6U W=0.405U AS=0.1782P AD=0.1053P PS=1.69U
+ PD=0.925U
M$104 \$64 \$63 VSS VSS nfet_05v0 L=0.6U W=0.405U AS=0.1053P AD=0.1782P
+ PS=0.925U PD=1.69U
M$105 \$77 MODE_Q VSS VSS nfet_05v0 L=0.6U W=0.36U AS=0.1584P AD=0.0936P
+ PS=1.6U PD=0.88U
M$106 \$78 \$63 \$77 VSS nfet_05v0 L=0.6U W=0.36U AS=0.0936P AD=0.0936P
+ PS=0.88U PD=0.88U
M$107 \$95 \$64 \$78 VSS nfet_05v0 L=0.6U W=0.36U AS=0.0936P AD=0.0432P
+ PS=0.88U PD=0.6U
M$108 \$96 \$80 \$95 VSS nfet_05v0 L=0.6U W=0.36U AS=0.0432P AD=0.0432P PS=0.6U
+ PD=0.6U
M$109 VSS RN|SETN \$96 VSS nfet_05v0 L=0.6U W=0.36U AS=0.0432P AD=0.2016P
+ PS=0.6U PD=1.48U
M$110 VSS \$78 \$80 VSS nfet_05v0 L=0.6U W=0.36U AS=0.2007P AD=0.2016P
+ PS=1.475U PD=1.48U
M$111 \$66 \$64 \$80 VSS nfet_05v0 L=0.6U W=0.36U AS=0.2007P AD=0.2007P
+ PS=1.475U PD=1.475U
M$112 \$82 \$63 \$66 VSS nfet_05v0 L=0.6U W=0.36U AS=0.2007P AD=0.0945P
+ PS=1.475U PD=0.885U
M$113 VSS \$83 \$82 VSS nfet_05v0 L=0.6U W=0.36U AS=0.0945P AD=0.1224P
+ PS=0.885U PD=1.04U
M$114 \$97 RN|SETN VSS VSS nfet_05v0 L=0.6U W=0.36U AS=0.1224P AD=0.134P
+ PS=1.04U PD=1.1U
M$115 \$83 \$66 \$97 VSS nfet_05v0 L=0.6U W=0.4U AS=0.134P AD=0.176P PS=1.1U
+ PD=1.68U
M$116 MODE_Q \$108 VSS VSS nfet_05v0 L=0.6U W=0.815U AS=0.3586P AD=0.3586P
+ PS=2.51U PD=2.51U
M$117 MODE_Q2 \$83 VSS VSS nfet_05v0 L=0.6U W=0.815U AS=0.3586P AD=0.3586P
+ PS=2.51U PD=2.51U
M$118 \$101 MODE VSS VSS nfet_05v0 L=0.6U W=0.36U AS=0.1584P AD=0.0936P PS=1.6U
+ PD=0.88U
M$119 \$104 \$99 \$101 VSS nfet_05v0 L=0.6U W=0.36U AS=0.0936P AD=0.0936P
+ PS=0.88U PD=0.88U
M$120 \$113 \$103 \$104 VSS nfet_05v0 L=0.6U W=0.36U AS=0.0936P AD=0.0432P
+ PS=0.88U PD=0.6U
M$121 \$115 \$105 \$113 VSS nfet_05v0 L=0.6U W=0.36U AS=0.0432P AD=0.0432P
+ PS=0.6U PD=0.6U
M$122 \$115 RN|SETN VSS VSS nfet_05v0 L=0.6U W=0.36U AS=0.2016P AD=0.0432P
+ PS=1.48U PD=0.6U
M$123 \$105 \$104 VSS VSS nfet_05v0 L=0.6U W=0.36U AS=0.2016P AD=0.2007P
+ PS=1.48U PD=1.475U
M$124 \$106 \$103 \$105 VSS nfet_05v0 L=0.6U W=0.36U AS=0.2007P AD=0.2007P
+ PS=1.475U PD=1.475U
M$125 \$107 \$99 \$106 VSS nfet_05v0 L=0.6U W=0.36U AS=0.2007P AD=0.0945P
+ PS=1.475U PD=0.885U
M$126 VSS \$108 \$107 VSS nfet_05v0 L=0.6U W=0.36U AS=0.0945P AD=0.1224P
+ PS=0.885U PD=1.04U
M$127 VSS RN|SETN \$114 VSS nfet_05v0 L=0.6U W=0.36U AS=0.134P AD=0.1224P
+ PS=1.1U PD=1.04U
M$128 \$108 \$106 \$114 VSS nfet_05v0 L=0.6U W=0.4U AS=0.134P AD=0.176P PS=1.1U
+ PD=1.68U
.ENDS MODE+FSM
