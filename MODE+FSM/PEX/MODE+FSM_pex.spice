* NGSPICE file created from MODE+FSM.ext - technology: gf180mcuD

.subckt dffsnq S0 SETN CLK VNW VPW a_1836_282# a_855_238# a_1492_238# a_3220_277#
+ a_1179_653# a_975_282# a_175_277# a_587_598# a_383_277# a_1432_653# a_2588_282#
+ a_2364_282# a_3268_233# a_383_598# a_1423_282#
X0 a_975_282# a_855_238# a_383_598# VNW pfet_05v0 ad=0.1313p pd=1.025u as=0.22725p ps=1.91u w=0.505u l=0.5u
X1 a_383_598# a_1492_238# a_1432_653# VNW pfet_05v0 ad=0.3975p pd=2.185u as=0.101p ps=0.905u w=0.505u l=0.5u
X2 a_1836_282# a_1179_653# a_383_277# VPW nfet_05v0 ad=86.39999f pd=0.84u as=93.59999f ps=0.88u w=0.36u l=0.6u
X3 a_587_598# a_175_277# a_383_598# VNW pfet_05v0 ad=0.3806p pd=2.61u as=0.2249p ps=1.385u w=0.865u l=0.5u
X4 a_1432_653# a_175_277# a_1179_653# VNW pfet_05v0 ad=0.101p pd=0.905u as=0.19315p ps=1.27u w=0.505u l=0.5u
X5 a_2364_282# a_175_277# a_1492_238# VNW pfet_05v0 ad=0.1079p pd=0.935u as=0.27805p ps=2.17u w=0.415u l=0.5u
X6 a_2588_282# SETN a_383_598# VNW pfet_05v0 ad=0.2028p pd=1.3u as=0.3432p ps=2.44u w=0.78u l=0.5u
X7 a_1179_653# a_175_277# a_975_282# VPW nfet_05v0 ad=93.59999f pd=0.88u as=93.59999f ps=0.88u w=0.36u l=0.6u
X8 a_383_277# a_3268_233# a_3220_277# VPW nfet_05v0 ad=0.14985p pd=1.145u as=48.6f ps=0.645u w=0.405u l=0.6u
X9 a_383_277# a_1492_238# a_1423_282# VPW nfet_05v0 ad=93.59999f pd=0.88u as=62.1f ps=0.705u w=0.36u l=0.6u
X10 a_2364_282# a_587_598# a_1492_238# VPW nfet_05v0 ad=93.59999f pd=0.88u as=0.1989p ps=1.465u w=0.36u l=0.6u
X11 a_1179_653# a_587_598# a_975_282# VNW pfet_05v0 ad=0.19315p pd=1.27u as=0.1313p ps=1.025u w=0.505u l=0.5u
X12 a_587_598# a_175_277# a_383_277# VPW nfet_05v0 ad=0.1782p pd=1.69u as=0.1053p ps=0.925u w=0.405u l=0.6u
X13 a_1492_238# SETN a_1836_282# VPW nfet_05v0 ad=0.1989p pd=1.465u as=86.39999f ps=0.84u w=0.36u l=0.6u
X14 a_2588_282# a_587_598# a_2364_282# VNW pfet_05v0 ad=0.1826p pd=1.71u as=0.1079p ps=0.935u w=0.415u l=0.5u
X15 a_383_598# a_3268_233# a_2588_282# VNW pfet_05v0 ad=0.3276p pd=1.62u as=0.2028p ps=1.3u w=0.78u l=0.5u
X16 a_975_282# a_855_238# a_383_277# VPW nfet_05v0 ad=93.59999f pd=0.88u as=0.1584p ps=1.6u w=0.36u l=0.6u
X17 a_3220_277# SETN a_2588_282# VPW nfet_05v0 ad=48.6f pd=0.645u as=0.3123p ps=2.38u w=0.405u l=0.6u
X18 a_383_277# CLK a_175_277# VPW nfet_05v0 ad=0.1053p pd=0.925u as=0.1782p ps=1.69u w=0.405u l=0.6u
X19 a_3268_233# a_2364_282# a_383_277# VPW nfet_05v0 ad=0.1782p pd=1.69u as=0.14985p ps=1.145u w=0.405u l=0.6u
X20 S0 a_3268_233# a_383_598# VNW pfet_05v0 ad=0.6561p pd=3.51u as=0.5346p ps=3.31u w=1.215u l=0.5u
X21 a_383_598# SETN a_1492_238# VNW pfet_05v0 ad=0.4149p pd=2.65u as=0.1521p ps=1.105u w=0.585u l=0.5u
X22 a_2588_282# a_175_277# a_2364_282# VPW nfet_05v0 ad=0.2898p pd=2.33u as=93.59999f ps=0.88u w=0.36u l=0.6u
X23 a_3268_233# a_2364_282# a_383_598# VNW pfet_05v0 ad=0.3432p pd=2.44u as=0.3276p ps=1.62u w=0.78u l=0.5u
X24 a_1492_238# a_1179_653# a_383_598# VNW pfet_05v0 ad=0.1521p pd=1.105u as=0.3975p ps=2.185u w=0.585u l=0.5u
X25 S0 a_3268_233# a_383_277# VPW nfet_05v0 ad=0.3586p pd=2.51u as=0.3586p ps=2.51u w=0.815u l=0.6u
X26 a_383_598# CLK a_175_277# VNW pfet_05v0 ad=0.2249p pd=1.385u as=0.3806p ps=2.61u w=0.865u l=0.5u
X27 a_1423_282# a_587_598# a_1179_653# VPW nfet_05v0 ad=62.1f pd=0.705u as=93.59999f ps=0.88u w=0.36u l=0.6u
C0 a_587_598# a_1423_282# 0.00269f
C1 a_3268_233# VNW 0.32346f
C2 CLK VNW 0.13659f
C3 a_3268_233# a_587_598# 0
C4 a_1432_653# a_1179_653# 0.00215f
C5 a_587_598# CLK 0.00131f
C6 SETN a_383_277# 0.00808f
C7 a_3268_233# a_2364_282# 0.51404f
C8 a_1179_653# VNW 0.22386f
C9 a_175_277# a_383_277# 0.28633f
C10 a_1179_653# a_587_598# 0.86961f
C11 a_2588_282# VNW 0.04382f
C12 a_587_598# a_2588_282# 0.05668f
C13 a_587_598# a_1836_282# 0.00762f
C14 a_975_282# a_1179_653# 0.06821f
C15 a_2588_282# a_2364_282# 0.56917f
C16 a_1492_238# a_383_598# 0.01626f
C17 SETN VNW 0.81105f
C18 a_175_277# a_1432_653# 0.00838f
C19 a_3220_277# a_2588_282# 0.0012f
C20 a_587_598# SETN 0.0839f
C21 S0 a_383_277# 0.13107f
C22 a_175_277# VNW 0.90944f
C23 a_855_238# a_1179_653# 0
C24 SETN a_2364_282# 0.0706f
C25 a_175_277# a_587_598# 0.47313f
C26 a_175_277# a_2364_282# 0.15368f
C27 a_383_598# a_3268_233# 0.35087f
C28 a_975_282# a_175_277# 0.0157f
C29 a_383_598# CLK 0.02209f
C30 a_383_598# a_1179_653# 0.03968f
C31 S0 VNW 0.03162f
C32 a_383_598# a_2588_282# 0.20863f
C33 a_587_598# S0 0
C34 a_855_238# a_175_277# 0.0927f
C35 S0 a_2364_282# 0
C36 a_1492_238# a_1179_653# 0.38742f
C37 a_383_598# SETN 0.12782f
C38 a_1492_238# a_2588_282# 0
C39 a_1492_238# a_1836_282# 0.00275f
C40 a_383_277# VNW 0.00654f
C41 a_175_277# a_383_598# 1.41468f
C42 a_587_598# a_383_277# 1.07431f
C43 a_1179_653# a_1423_282# 0
C44 a_383_277# a_2364_282# 1.18908f
C45 a_975_282# a_383_277# 0.05001f
C46 a_1492_238# SETN 0.07298f
C47 a_3268_233# a_2588_282# 0.00955f
C48 a_1492_238# a_175_277# 0.84088f
C49 a_383_598# S0 0.28194f
C50 a_855_238# a_383_277# 0.06788f
C51 a_587_598# VNW 0.40096f
C52 a_3268_233# SETN 0.08929f
C53 a_2364_282# VNW 0.20903f
C54 a_975_282# VNW 0.01368f
C55 a_175_277# a_3268_233# 0
C56 a_587_598# a_2364_282# 0.154f
C57 a_175_277# CLK 0.70097f
C58 a_975_282# a_587_598# 0.42776f
C59 a_1179_653# SETN 0.06324f
C60 SETN a_2588_282# 0.30222f
C61 a_383_598# a_383_277# 0.01004f
C62 a_175_277# a_1179_653# 0.20639f
C63 a_3220_277# a_2364_282# 0.00413f
C64 a_855_238# VNW 0.1615f
C65 a_175_277# a_2588_282# 0.00597f
C66 a_855_238# a_587_598# 0.4001f
C67 a_3268_233# S0 0.17947f
C68 a_855_238# a_975_282# 0.1081f
C69 a_1492_238# a_383_277# 0.02735f
C70 a_175_277# SETN 0.07777f
C71 a_383_598# VNW 0.52937f
C72 a_383_598# a_587_598# 0.62458f
C73 a_1423_282# a_383_277# 0.00364f
C74 a_383_598# a_2364_282# 0.07341f
C75 a_1492_238# a_1432_653# 0
C76 a_3268_233# a_383_277# 0.1363f
C77 CLK a_383_277# 0.02194f
C78 a_383_598# a_3220_277# 0
C79 a_1492_238# VNW 0.21951f
C80 a_1492_238# a_587_598# 0.31725f
C81 a_1179_653# a_383_277# 0.06022f
C82 a_175_277# S0 0
C83 a_1492_238# a_2364_282# 0.15287f
C84 a_855_238# a_383_598# 0.00494f
C85 S0 VPW 0.10557f
C86 SETN VPW 0.71025f
C87 CLK VPW 0.29047f
C88 VNW VPW 6.44257f
C89 a_2588_282# VPW 0.04999f
C90 a_383_277# VPW 1.33437f
C91 a_2364_282# VPW 0.43408f
C92 a_3268_233# VPW 0.58406f
C93 a_975_282# VPW 0.01977f
C94 a_1179_653# VPW 0.30208f
C95 a_1492_238# VPW 0.28651f
C96 a_855_238# VPW 0.2471f
C97 a_587_598# VPW 1.21246f
C98 a_383_598# VPW 0.81731f
C99 a_175_277# VPW 1.31409f
.ends

.subckt or2 MODE_Q2 VNW VPW a_n505_n1653# a_159_n1784# a_n525_n2163# a_n437_n2208#
+ a_n317_n1653# a_n113_n1653#
X0 a_159_n1784# a_n505_n1653# a_n113_n1653# VNW pfet_05v0 ad=0.5368p pd=3.32u as=0.38705p ps=2.08u w=1.22u l=0.5u
X1 a_n317_n1653# a_n437_n2208# a_n505_n1653# VNW pfet_05v0 ad=0.1469p pd=1.085u as=0.2486p ps=2.01u w=0.565u l=0.5u
X2 a_159_n1784# a_n505_n1653# a_n525_n2163# VPW nfet_05v0 ad=0.3608p pd=2.52u as=0.2288p ps=1.58u w=0.82u l=0.6u
X3 a_n113_n1653# MODE_Q2 a_n317_n1653# VNW pfet_05v0 ad=0.38705p pd=2.08u as=0.1469p ps=1.085u w=0.565u l=0.5u
X4 a_n525_n2163# MODE_Q2 a_n505_n1653# VPW nfet_05v0 ad=0.2288p pd=1.58u as=93.59999f ps=0.88u w=0.36u l=0.6u
X5 a_n505_n1653# a_n437_n2208# a_n525_n2163# VPW nfet_05v0 ad=93.59999f pd=0.88u as=0.1584p ps=1.6u w=0.36u l=0.6u
C0 a_159_n1784# a_n113_n1653# 0.19605f
C1 a_n525_n2163# a_n317_n1653# 0
C2 a_n505_n1653# VNW 0.15724f
C3 MODE_Q2 a_n113_n1653# 0.14763f
C4 a_159_n1784# a_n505_n1653# 0.18159f
C5 a_n113_n1653# a_n437_n2208# 0.01431f
C6 MODE_Q2 a_n505_n1653# 0.50537f
C7 a_n525_n2163# a_n113_n1653# 0.00865f
C8 a_n505_n1653# a_n437_n2208# 0.54089f
C9 a_n525_n2163# a_n505_n1653# 0.25049f
C10 a_159_n1784# VNW 0.03388f
C11 a_n317_n1653# a_n113_n1653# 0.00536f
C12 MODE_Q2 VNW 0.21631f
C13 MODE_Q2 a_159_n1784# 0.0276f
C14 VNW a_n437_n2208# 0.22f
C15 a_n505_n1653# a_n317_n1653# 0.00762f
C16 a_n525_n2163# VNW 0.01004f
C17 MODE_Q2 a_n437_n2208# 0.0624f
C18 a_n525_n2163# a_159_n1784# 0.15826f
C19 a_n505_n1653# a_n113_n1653# 0.30704f
C20 MODE_Q2 a_n525_n2163# 0.02575f
C21 a_n525_n2163# a_n437_n2208# 0.05074f
C22 MODE_Q2 a_n317_n1653# 0.00196f
C23 VNW a_n113_n1653# 0.11771f
C24 MODE_Q2 VPW 0.31344f
C25 VNW VPW 1.65967f
C26 a_n525_n2163# VPW 0.35972f
C27 a_159_n1784# VPW 0.10275f
C28 a_n113_n1653# VPW 0.23302f
C29 a_n505_n1653# VPW 0.34568f
C30 a_n437_n2208# VPW 0.39469f
.ends

.subckt nor2 REC_EN TREAT_EN A2 VSS VDD w_1180_n1958# a_1490_n1804# VSUBS
X0 a_1490_n1804# REC_EN VDD w_1180_n1958# pfet_05v0 ad=0.4087p pd=1.89u as=0.5368p ps=3.32u w=1.22u l=0.5u
X1 TREAT_EN REC_EN VSS VSUBS nfet_05v0 ad=0.1469p pd=1.085u as=0.2486p ps=2.01u w=0.565u l=0.6u
X2 TREAT_EN A2 a_1490_n1804# w_1180_n1958# pfet_05v0 ad=0.5368p pd=3.32u as=0.4087p ps=1.89u w=1.22u l=0.5u
X3 VSS A2 TREAT_EN VSUBS nfet_05v0 ad=0.2486p pd=2.01u as=0.1469p ps=1.085u w=0.565u l=0.6u
C0 VDD A2 0.0227f
C1 w_1180_n1958# VDD 0.09421f
C2 REC_EN A2 0.03781f
C3 a_1490_n1804# TREAT_EN 0.02369f
C4 w_1180_n1958# REC_EN 0.1288f
C5 TREAT_EN A2 0.57853f
C6 w_1180_n1958# TREAT_EN 0.01978f
C7 a_1490_n1804# VSS 0
C8 REC_EN VDD 0.25532f
C9 VSS A2 0.16225f
C10 VDD TREAT_EN 0.11792f
C11 w_1180_n1958# VSS 0.01214f
C12 REC_EN TREAT_EN 0.37841f
C13 w_1180_n1958# A2 0.13314f
C14 VDD VSS 0.02591f
C15 REC_EN VSS 0.04452f
C16 a_1490_n1804# VDD 0.01396f
C17 VSS TREAT_EN 0.08738f
C18 REC_EN a_1490_n1804# 0.00898f
C19 VDD VSUBS 0.21903f
C20 TREAT_EN VSUBS 0.05889f
C21 VSS VSUBS 0.3776f
C22 A2 VSUBS 0.32864f
C23 REC_EN VSUBS 0.33451f
C24 w_1180_n1958# VSUBS 1.31158f
.ends

.subckt dffrnq S1 RN CLK VNW VPW a_1002_n2102# a_1458_n1702# a_2250_n1702# a_2667_n1842#
+ a_38_n1706# a_798_n2102# a_698_n2146# a_450_n2119# a_1310_n2146# a_246_n2119# a_246_n1706#
+ a_1206_n2102# a_1290_n1702# a_2562_n1702# a_3043_n1702#
X0 a_246_n1706# RN a_1458_n1702# VPW nfet_05v0 ad=0.2016p pd=1.48u as=43.2f ps=0.6u w=0.36u l=0.6u
X1 a_3043_n1702# RN a_246_n1706# VPW nfet_05v0 ad=0.134p pd=1.1u as=0.1224p ps=1.04u w=0.36u l=0.6u
X2 a_2562_n1702# a_450_n2119# a_2250_n1702# VNW pfet_05v0 ad=0.1313p pd=1.025u as=0.25375p ps=1.51u w=0.505u l=0.5u
X3 a_798_n2102# a_698_n2146# a_246_n2119# VNW pfet_05v0 ad=0.2028p pd=1.3u as=0.3432p ps=2.44u w=0.78u l=0.5u
X4 a_246_n1706# a_2667_n1842# a_2562_n1702# VPW nfet_05v0 ad=0.1224p pd=1.04u as=94.5f ps=0.885u w=0.36u l=0.6u
X5 a_450_n2119# a_38_n1706# a_246_n1706# VPW nfet_05v0 ad=0.1782p pd=1.69u as=0.1053p ps=0.925u w=0.405u l=0.6u
X6 a_1206_n2102# a_38_n1706# a_1002_n2102# VNW pfet_05v0 ad=0.2028p pd=1.3u as=0.2028p ps=1.3u w=0.78u l=0.5u
X7 a_2667_n1842# a_2250_n1702# a_3043_n1702# VPW nfet_05v0 ad=0.176p pd=1.68u as=0.134p ps=1.1u w=0.4u l=0.6u
X8 a_1206_n2102# RN a_246_n2119# VNW pfet_05v0 ad=0.3432p pd=2.44u as=0.45p ps=2.02u w=0.78u l=0.5u
X9 a_2562_n1702# a_38_n1706# a_2250_n1702# VPW nfet_05v0 ad=94.5f pd=0.885u as=0.2007p ps=1.475u w=0.36u l=0.6u
X10 a_246_n1706# CLK a_38_n1706# VPW nfet_05v0 ad=0.1053p pd=0.925u as=0.1782p ps=1.69u w=0.405u l=0.6u
X11 a_1310_n2146# a_1002_n2102# a_246_n2119# VNW pfet_05v0 ad=0.2424p pd=1.465u as=0.2222p ps=1.89u w=0.505u l=0.5u
X12 a_2667_n1842# RN a_246_n2119# VNW pfet_05v0 ad=0.26p pd=1.52u as=0.29465p ps=1.74u w=1u l=0.5u
X13 a_2250_n1702# a_450_n2119# a_1310_n2146# VPW nfet_05v0 ad=0.2007p pd=1.475u as=0.2007p ps=1.475u w=0.36u l=0.6u
X14 a_246_n2119# CLK a_38_n1706# VNW pfet_05v0 ad=0.2249p pd=1.385u as=0.3806p ps=2.61u w=0.865u l=0.5u
X15 a_246_n2119# a_2667_n1842# a_2562_n1702# VNW pfet_05v0 ad=0.29465p pd=1.74u as=0.1313p ps=1.025u w=0.505u l=0.5u
X16 a_1290_n1702# a_450_n2119# a_1002_n2102# VPW nfet_05v0 ad=43.2f pd=0.6u as=93.59999f ps=0.88u w=0.36u l=0.6u
X17 S1 a_2667_n1842# a_246_n2119# VNW pfet_05v0 ad=0.63787p pd=3.48u as=0.5346p ps=3.31u w=1.215u l=0.5u
X18 a_246_n2119# a_1310_n2146# a_1206_n2102# VNW pfet_05v0 ad=0.45p pd=2.02u as=0.2028p ps=1.3u w=0.78u l=0.5u
X19 S1 a_2667_n1842# a_246_n1706# VPW nfet_05v0 ad=0.42787p pd=2.68u as=0.3586p ps=2.51u w=0.815u l=0.6u
X20 a_798_n2102# a_698_n2146# a_246_n1706# VPW nfet_05v0 ad=93.59999f pd=0.88u as=0.1584p ps=1.6u w=0.36u l=0.6u
X21 a_2250_n1702# a_38_n1706# a_1310_n2146# VNW pfet_05v0 ad=0.25375p pd=1.51u as=0.2424p ps=1.465u w=0.505u l=0.5u
X22 a_246_n2119# a_2250_n1702# a_2667_n1842# VNW pfet_05v0 ad=0.44p pd=2.88u as=0.26p ps=1.52u w=1u l=0.5u
X23 a_1002_n2102# a_38_n1706# a_798_n2102# VPW nfet_05v0 ad=93.59999f pd=0.88u as=93.59999f ps=0.88u w=0.36u l=0.6u
X24 a_450_n2119# a_38_n1706# a_246_n2119# VNW pfet_05v0 ad=0.3806p pd=2.61u as=0.2249p ps=1.385u w=0.865u l=0.5u
X25 a_1002_n2102# a_450_n2119# a_798_n2102# VNW pfet_05v0 ad=0.2028p pd=1.3u as=0.2028p ps=1.3u w=0.78u l=0.5u
X26 a_1458_n1702# a_1310_n2146# a_1290_n1702# VPW nfet_05v0 ad=43.2f pd=0.6u as=43.2f ps=0.6u w=0.36u l=0.6u
X27 a_1310_n2146# a_1002_n2102# a_246_n1706# VPW nfet_05v0 ad=0.2007p pd=1.475u as=0.2016p ps=1.48u w=0.36u l=0.6u
C0 VNW a_1206_n2102# 0.01627f
C1 VNW a_38_n1706# 1.28833f
C2 a_798_n2102# a_246_n2119# 0
C3 a_798_n2102# a_450_n2119# 0.40164f
C4 a_246_n1706# a_1290_n1702# 0.0017f
C5 a_2250_n1702# a_38_n1706# 0.0428f
C6 a_2667_n1842# a_3043_n1702# 0.00177f
C7 VNW a_798_n2102# 0.01023f
C8 a_1310_n2146# a_246_n1706# 0.01482f
C9 a_698_n2146# a_38_n1706# 0.09411f
C10 a_1458_n1702# a_246_n1706# 0.0019f
C11 a_2562_n1702# a_38_n1706# 0.00367f
C12 RN a_3043_n1702# 0.01068f
C13 RN a_1310_n2146# 0.07929f
C14 a_2667_n1842# a_38_n1706# 0.01904f
C15 a_798_n2102# a_698_n2146# 0.08286f
C16 a_246_n1706# a_38_n1706# 0.29961f
C17 a_1002_n2102# a_246_n2119# 0.11921f
C18 a_1002_n2102# a_450_n2119# 0.36196f
C19 RN a_1206_n2102# 0.02104f
C20 VNW a_1002_n2102# 0.24136f
C21 a_798_n2102# a_246_n1706# 0.05215f
C22 RN a_38_n1706# 0.0801f
C23 CLK a_246_n2119# 0.02303f
C24 CLK a_450_n2119# 0.00276f
C25 a_2250_n1702# a_1002_n2102# 0.00123f
C26 S1 a_38_n1706# 0
C27 CLK VNW 0.13704f
C28 a_1002_n2102# a_698_n2146# 0
C29 a_450_n2119# a_246_n2119# 0.45627f
C30 VNW a_246_n2119# 0.50314f
C31 VNW a_450_n2119# 0.34128f
C32 a_1002_n2102# a_246_n1706# 0.04356f
C33 a_2250_n1702# a_246_n2119# 1.11667f
C34 a_2250_n1702# a_450_n2119# 0.51037f
C35 a_246_n2119# a_698_n2146# 0.00937f
C36 a_450_n2119# a_698_n2146# 0.32879f
C37 VNW a_2250_n1702# 0.21243f
C38 RN a_1002_n2102# 0.0832f
C39 CLK a_246_n1706# 0.02288f
C40 VNW a_698_n2146# 0.12823f
C41 a_246_n2119# a_2562_n1702# 0.00217f
C42 a_450_n2119# a_2562_n1702# 0.27749f
C43 a_2667_n1842# a_246_n2119# 0.10205f
C44 a_2667_n1842# a_450_n2119# 0.02046f
C45 a_246_n1706# a_246_n2119# 0.01338f
C46 a_246_n1706# a_450_n2119# 1.20327f
C47 a_1310_n2146# a_1206_n2102# 0.02667f
C48 VNW a_2562_n1702# 0.02016f
C49 a_1310_n2146# a_38_n1706# 0.05539f
C50 a_2667_n1842# VNW 0.35472f
C51 VNW a_246_n1706# 0.0106f
C52 a_2250_n1702# a_2562_n1702# 0.11969f
C53 RN a_246_n2119# 0.03498f
C54 a_2667_n1842# a_2250_n1702# 0.63332f
C55 RN a_450_n2119# 0.07873f
C56 a_2250_n1702# a_246_n1706# 0.03193f
C57 a_1206_n2102# a_38_n1706# 0.007f
C58 RN VNW 0.32949f
C59 a_246_n1706# a_698_n2146# 0.06462f
C60 S1 a_246_n2119# 0.1499f
C61 a_2667_n1842# a_2562_n1702# 0.11606f
C62 RN a_2250_n1702# 0.09434f
C63 VNW S1 0.03166f
C64 a_798_n2102# a_38_n1706# 0.01185f
C65 a_246_n1706# a_2562_n1702# 0.1285f
C66 a_2667_n1842# a_246_n1706# 0.18639f
C67 a_1002_n2102# a_1290_n1702# 0
C68 S1 a_2250_n1702# 0.01436f
C69 a_1002_n2102# a_1310_n2146# 0.93419f
C70 RN a_2562_n1702# 0.03878f
C71 RN a_2667_n1842# 0.33647f
C72 RN a_246_n1706# 0.45994f
C73 a_1458_n1702# a_1002_n2102# 0
C74 a_2667_n1842# S1 0.10944f
C75 a_1002_n2102# a_1206_n2102# 0.66083f
C76 a_1002_n2102# a_38_n1706# 0.08126f
C77 S1 a_246_n1706# 0.11398f
C78 a_450_n2119# a_1290_n1702# 0.00207f
C79 a_1310_n2146# a_246_n2119# 0.09419f
C80 a_1310_n2146# a_450_n2119# 0.8821f
C81 a_1002_n2102# a_798_n2102# 0.04844f
C82 RN S1 0
C83 CLK a_38_n1706# 0.6696f
C84 VNW a_1310_n2146# 0.14901f
C85 a_1458_n1702# a_450_n2119# 0.00227f
C86 a_246_n2119# a_1206_n2102# 0.28263f
C87 a_450_n2119# a_1206_n2102# 0.009f
C88 a_246_n2119# a_38_n1706# 0.41709f
C89 a_2250_n1702# a_1310_n2146# 0.05672f
C90 a_450_n2119# a_38_n1706# 0.53697f
C91 S1 VPW 0.11299f
C92 RN VPW 1.36673f
C93 CLK VPW 0.29124f
C94 VNW VPW 6.1377f
C95 a_1206_n2102# VPW 0.01297f
C96 a_246_n2119# VPW 0.79945f
C97 a_2562_n1702# VPW 0.01697f
C98 a_2250_n1702# VPW 0.37166f
C99 a_2667_n1842# VPW 0.62251f
C100 a_1002_n2102# VPW 0.29173f
C101 a_798_n2102# VPW 0.02321f
C102 a_1310_n2146# VPW 0.27904f
C103 a_698_n2146# VPW 0.25341f
C104 a_450_n2119# VPW 0.68441f
C105 a_246_n1706# VPW 1.42701f
C106 a_38_n1706# VPW 1.43589f
.ends

.subckt MODEdffrnq1 RN VSS CLK VDD VNW VPW a_9844_4849# a_8007_5165# a_8259_4849#
+ a_7251_5165# a_8111_5116# a_9363_4849# a_6839_4844# a_9468_4805# a_7599_5165# a_8091_4849#
+ a_9051_4849# a_10472_4762# a_7803_5165# a_7499_4995#
X0 VDD a_9468_4805# a_9363_4849# VNW pfet_05v0 ad=0.29465p pd=1.74u as=0.1313p ps=1.025u w=0.505u l=0.5u
X1 VSS RN a_8259_4849# VPW nfet_05v0 ad=0.2016p pd=1.48u as=43.2f ps=0.6u w=0.36u l=0.6u
X2 a_7599_5165# a_7499_4995# VSS VPW nfet_05v0 ad=93.59999f pd=0.88u as=0.1584p ps=1.6u w=0.36u l=0.6u
X3 a_8091_4849# a_7251_5165# a_7803_5165# VPW nfet_05v0 ad=43.2f pd=0.6u as=93.59999f ps=0.88u w=0.36u l=0.6u
X4 a_8259_4849# a_8111_5116# a_8091_4849# VPW nfet_05v0 ad=43.2f pd=0.6u as=43.2f ps=0.6u w=0.36u l=0.6u
X5 a_9844_4849# RN VSS VPW nfet_05v0 ad=0.134p pd=1.1u as=0.1224p ps=1.04u w=0.36u l=0.6u
X6 a_9468_4805# a_9051_4849# a_9844_4849# VPW nfet_05v0 ad=0.176p pd=1.68u as=0.134p ps=1.1u w=0.4u l=0.6u
X7 a_9051_4849# a_7251_5165# a_8111_5116# VPW nfet_05v0 ad=0.2007p pd=1.475u as=0.2007p ps=1.475u w=0.36u l=0.6u
X8 a_9051_4849# a_6839_4844# a_8111_5116# VNW pfet_05v0 ad=0.25375p pd=1.51u as=0.2424p ps=1.465u w=0.505u l=0.5u
X9 a_9363_4849# a_7251_5165# a_9051_4849# VNW pfet_05v0 ad=0.1313p pd=1.025u as=0.25375p ps=1.51u w=0.505u l=0.5u
X10 a_7803_5165# a_7251_5165# a_7599_5165# VNW pfet_05v0 ad=0.2028p pd=1.3u as=0.2028p ps=1.3u w=0.78u l=0.5u
X11 a_8007_5165# RN VDD VNW pfet_05v0 ad=0.3432p pd=2.44u as=0.45p ps=2.02u w=0.78u l=0.5u
X12 VSS CLK a_6839_4844# VPW nfet_05v0 ad=0.1053p pd=0.925u as=0.1782p ps=1.69u w=0.405u l=0.6u
X13 a_8111_5116# a_7803_5165# VSS VPW nfet_05v0 ad=0.2007p pd=1.475u as=0.2016p ps=1.48u w=0.36u l=0.6u
X14 VDD a_9051_4849# a_9468_4805# VNW pfet_05v0 ad=0.44p pd=2.88u as=0.26p ps=1.52u w=1u l=0.5u
X15 VSS a_9468_4805# a_9363_4849# VPW nfet_05v0 ad=0.1224p pd=1.04u as=94.5f ps=0.885u w=0.36u l=0.6u
X16 VDD CLK a_6839_4844# VNW pfet_05v0 ad=0.2249p pd=1.385u as=0.3806p ps=2.61u w=0.865u l=0.5u
X17 a_10472_4762# a_9468_4805# VSS VPW nfet_05v0 ad=0.3586p pd=2.51u as=0.3586p ps=2.51u w=0.815u l=0.6u
X18 a_7251_5165# a_6839_4844# VDD VNW pfet_05v0 ad=0.3806p pd=2.61u as=0.2249p ps=1.385u w=0.865u l=0.5u
X19 a_7599_5165# a_7499_4995# VDD VNW pfet_05v0 ad=0.2028p pd=1.3u as=0.3432p ps=2.44u w=0.78u l=0.5u
X20 a_8007_5165# a_6839_4844# a_7803_5165# VNW pfet_05v0 ad=0.2028p pd=1.3u as=0.2028p ps=1.3u w=0.78u l=0.5u
X21 a_8111_5116# a_7803_5165# VDD VNW pfet_05v0 ad=0.2424p pd=1.465u as=0.2222p ps=1.89u w=0.505u l=0.5u
X22 VDD a_8111_5116# a_8007_5165# VNW pfet_05v0 ad=0.45p pd=2.02u as=0.2028p ps=1.3u w=0.78u l=0.5u
X23 a_7251_5165# a_6839_4844# VSS VPW nfet_05v0 ad=0.1782p pd=1.69u as=0.1053p ps=0.925u w=0.405u l=0.6u
X24 a_7803_5165# a_6839_4844# a_7599_5165# VPW nfet_05v0 ad=93.59999f pd=0.88u as=93.59999f ps=0.88u w=0.36u l=0.6u
X25 a_9468_4805# RN VDD VNW pfet_05v0 ad=0.26p pd=1.52u as=0.29465p ps=1.74u w=1u l=0.5u
X26 a_10472_4762# a_9468_4805# VDD VNW pfet_05v0 ad=0.5346p pd=3.31u as=0.5346p ps=3.31u w=1.215u l=0.5u
X27 a_9363_4849# a_6839_4844# a_9051_4849# VPW nfet_05v0 ad=94.5f pd=0.885u as=0.2007p ps=1.475u w=0.36u l=0.6u
C0 a_8111_5116# a_7251_5165# 0.8821f
C1 a_9468_4805# VNW 0.35472f
C2 a_7599_5165# a_7499_4995# 0.08286f
C3 a_9363_4849# a_6839_4844# 0.00367f
C4 a_9363_4849# RN 0.03878f
C5 a_9468_4805# a_9051_4849# 0.63332f
C6 a_10472_4762# a_9468_4805# 0.10944f
C7 a_7499_4995# a_6839_4844# 0.09411f
C8 a_9468_4805# VDD 0.10375f
C9 a_7251_5165# VNW 0.34128f
C10 VNW CLK 0.13704f
C11 a_7803_5165# a_8091_4849# 0
C12 a_7251_5165# a_9051_4849# 0.51037f
C13 a_7599_5165# VSS 0.05215f
C14 a_9363_4849# VNW 0.02016f
C15 VDD a_7251_5165# 0.45687f
C16 VDD CLK 0.02371f
C17 VSS a_6839_4844# 0.29961f
C18 VSS RN 0.45994f
C19 a_7499_4995# VNW 0.12823f
C20 a_7803_5165# a_8259_4849# 0
C21 a_9363_4849# a_9051_4849# 0.11969f
C22 VSS a_8111_5116# 0.01482f
C23 a_7803_5165# a_7251_5165# 0.36196f
C24 a_9363_4849# VDD 0.00217f
C25 a_7599_5165# a_6839_4844# 0.01185f
C26 a_7499_4995# VDD 0.00937f
C27 a_8007_5165# a_7251_5165# 0.009f
C28 VSS VNW 0.0106f
C29 RN a_6839_4844# 0.0801f
C30 a_7803_5165# a_7499_4995# 0
C31 a_8111_5116# a_6839_4844# 0.05539f
C32 VSS a_9051_4849# 0.03193f
C33 a_8111_5116# RN 0.07929f
C34 VSS a_10472_4762# 0.1134f
C35 VSS VDD 0.01338f
C36 a_7599_5165# VNW 0.01023f
C37 a_9844_4849# RN 0.01068f
C38 a_6839_4844# VNW 1.28833f
C39 RN VNW 0.32949f
C40 a_7803_5165# VSS 0.04356f
C41 a_7599_5165# VDD 0
C42 a_8111_5116# VNW 0.14901f
C43 a_6839_4844# a_9051_4849# 0.0428f
C44 a_8091_4849# a_7251_5165# 0.00207f
C45 RN a_9051_4849# 0.09434f
C46 a_10472_4762# a_6839_4844# 0
C47 a_10472_4762# RN 0
C48 VDD a_6839_4844# 0.43586f
C49 VDD RN 0.03608f
C50 a_9468_4805# a_7251_5165# 0.02046f
C51 a_8111_5116# a_9051_4849# 0.05672f
C52 a_7803_5165# a_7599_5165# 0.04844f
C53 a_8111_5116# VDD 0.09419f
C54 a_8259_4849# a_7251_5165# 0.00227f
C55 a_7803_5165# a_6839_4844# 0.08126f
C56 a_7803_5165# RN 0.0832f
C57 a_9363_4849# a_9468_4805# 0.11606f
C58 a_7251_5165# CLK 0.00276f
C59 a_9051_4849# VNW 0.21243f
C60 a_10472_4762# VNW 0.03444f
C61 a_7803_5165# a_8111_5116# 0.93419f
C62 VDD VNW 0.54136f
C63 a_8007_5165# a_6839_4844# 0.007f
C64 a_8007_5165# RN 0.02104f
C65 a_10472_4762# a_9051_4849# 0.01436f
C66 a_9363_4849# a_7251_5165# 0.27749f
C67 a_8111_5116# a_8007_5165# 0.02667f
C68 VDD a_9051_4849# 1.11763f
C69 a_10472_4762# VDD 0.14934f
C70 a_7803_5165# VNW 0.24136f
C71 VSS a_8091_4849# 0.0017f
C72 a_7499_4995# a_7251_5165# 0.32879f
C73 VSS a_9468_4805# 0.18639f
C74 a_7803_5165# a_9051_4849# 0.00123f
C75 a_8007_5165# VNW 0.01627f
C76 a_7803_5165# VDD 0.11921f
C77 VSS a_8259_4849# 0.0019f
C78 VSS a_7251_5165# 1.20327f
C79 VSS CLK 0.02288f
C80 a_8007_5165# VDD 0.28263f
C81 a_9468_4805# a_6839_4844# 0.01904f
C82 a_9468_4805# RN 0.33647f
C83 VSS a_9363_4849# 0.1285f
C84 a_7599_5165# a_7251_5165# 0.40164f
C85 a_7803_5165# a_8007_5165# 0.66083f
C86 VSS a_7499_4995# 0.06462f
C87 a_6839_4844# a_7251_5165# 0.53697f
C88 RN a_7251_5165# 0.07873f
C89 a_6839_4844# CLK 0.6696f
C90 a_9844_4849# a_9468_4805# 0.00177f
C91 VSS VPW 1.42743f
C92 RN VPW 1.36673f
C93 VDD VPW 0.88901f
C94 CLK VPW 0.29124f
C95 VNW VPW 6.1377f
C96 a_10472_4762# VPW 0.11476f
C97 a_9363_4849# VPW 0.01697f
C98 a_9468_4805# VPW 0.62251f
C99 a_9051_4849# VPW 0.37166f
C100 a_8007_5165# VPW 0.01297f
C101 a_7803_5165# VPW 0.29173f
C102 a_7599_5165# VPW 0.02321f
C103 a_8111_5116# VPW 0.27904f
C104 a_7499_4995# VPW 0.25341f
C105 a_7251_5165# VPW 0.68441f
C106 a_6839_4844# VPW 1.43589f
.ends

.subckt and2 VNW VPW a_3638_891# a_3366_452# a_3758_935# a_3366_935# a_3574_935# a_3454_407#
+ a_4026_452#
X0 a_4026_452# a_3366_935# a_3366_452# VNW pfet_05v0 ad=0.5346p pd=3.31u as=0.40575p ps=2.055u w=1.215u l=0.5u
X1 a_3758_935# a_3638_891# a_3574_935# VPW nfet_05v0 ad=0.23405p pd=1.555u as=58.39999f ps=0.685u w=0.365u l=0.6u
X2 a_3366_935# a_3454_407# a_3366_452# VNW pfet_05v0 ad=0.156p pd=1.12u as=0.264p ps=2.08u w=0.6u l=0.5u
X3 a_3574_935# a_3454_407# a_3366_935# VPW nfet_05v0 ad=58.39999f pd=0.685u as=0.1606p ps=1.61u w=0.365u l=0.6u
X4 a_3366_452# a_3638_891# a_3366_935# VNW pfet_05v0 ad=0.40575p pd=2.055u as=0.156p ps=1.12u w=0.6u l=0.5u
X5 a_4026_452# a_3366_935# a_3758_935# VPW nfet_05v0 ad=0.3586p pd=2.51u as=0.23405p ps=1.555u w=0.815u l=0.6u
C0 a_3454_407# a_3638_891# 0.06143f
C1 a_3758_935# a_3574_935# 0.00145f
C2 a_3366_935# a_3454_407# 0.37712f
C3 a_3454_407# a_4026_452# 0
C4 a_3366_935# a_3574_935# 0.00334f
C5 a_4026_452# a_3574_935# 0
C6 a_3366_452# VNW 0.12561f
C7 a_3758_935# VNW 0.00793f
C8 a_3758_935# a_3366_452# 0.01413f
C9 VNW a_3638_891# 0.20463f
C10 a_3366_452# a_3638_891# 0.18402f
C11 a_3366_935# VNW 0.1625f
C12 a_3366_935# a_3366_452# 0.13019f
C13 a_4026_452# VNW 0.03284f
C14 a_4026_452# a_3366_452# 0.15821f
C15 a_3758_935# a_3638_891# 0.01199f
C16 a_3366_935# a_3758_935# 0.24575f
C17 a_3758_935# a_4026_452# 0.10282f
C18 a_3366_935# a_3638_891# 0.47278f
C19 a_4026_452# a_3638_891# 0.02017f
C20 a_3366_935# a_4026_452# 0.21527f
C21 a_3454_407# VNW 0.20677f
C22 a_3454_407# a_3366_452# 0.04397f
C23 a_3454_407# a_3758_935# 0.01116f
C24 VNW VPW 1.65967f
C25 a_3366_452# VPW 0.25125f
C26 a_4026_452# VPW 0.09648f
C27 a_3638_891# VPW 0.26226f
C28 a_3454_407# VPW 0.32127f
C29 a_3758_935# VPW 0.40776f
C30 a_3366_935# VPW 0.37412f
.ends

.subckt MODEdffrnq0 VDD CLK VSS RN MODE VNW VPW a_7269_n20# a_7929_n336# a_10142_n423#
+ a_7781_n69# a_6509_n341# a_7761_n336# a_8721_n336# a_9514_n336# a_7677_n20# a_7473_n20#
+ a_6921_n20# a_9033_n336# a_9138_n380#
X0 VDD a_8721_n336# a_9138_n380# VNW pfet_05v0 ad=0.44p pd=2.88u as=0.26p ps=1.52u w=1u l=0.5u
X1 a_9033_n336# a_6509_n341# a_8721_n336# VPW nfet_05v0 ad=94.5f pd=0.885u as=0.2007p ps=1.475u w=0.36u l=0.6u
X2 VDD a_7781_n69# a_7677_n20# VNW pfet_05v0 ad=0.45p pd=2.02u as=0.2028p ps=1.3u w=0.78u l=0.5u
X3 a_7781_n69# a_7473_n20# VSS VPW nfet_05v0 ad=0.2007p pd=1.475u as=0.2016p ps=1.48u w=0.36u l=0.6u
X4 a_7929_n336# a_7781_n69# a_7761_n336# VPW nfet_05v0 ad=43.2f pd=0.6u as=43.2f ps=0.6u w=0.36u l=0.6u
X5 a_9138_n380# a_8721_n336# a_9514_n336# VPW nfet_05v0 ad=0.176p pd=1.68u as=0.134p ps=1.1u w=0.4u l=0.6u
X6 VDD a_9138_n380# a_9033_n336# VNW pfet_05v0 ad=0.29465p pd=1.74u as=0.1313p ps=1.025u w=0.505u l=0.5u
X7 a_7473_n20# a_6509_n341# a_7269_n20# VPW nfet_05v0 ad=93.59999f pd=0.88u as=93.59999f ps=0.88u w=0.36u l=0.6u
X8 VSS RN a_7929_n336# VPW nfet_05v0 ad=0.2016p pd=1.48u as=43.2f ps=0.6u w=0.36u l=0.6u
X9 a_9033_n336# a_6921_n20# a_8721_n336# VNW pfet_05v0 ad=0.1313p pd=1.025u as=0.25375p ps=1.51u w=0.505u l=0.5u
X10 VDD CLK a_6509_n341# VNW pfet_05v0 ad=0.2249p pd=1.385u as=0.3806p ps=2.61u w=0.865u l=0.5u
X11 a_7761_n336# a_6921_n20# a_7473_n20# VPW nfet_05v0 ad=43.2f pd=0.6u as=93.59999f ps=0.88u w=0.36u l=0.6u
X12 a_6921_n20# a_6509_n341# VDD VNW pfet_05v0 ad=0.3806p pd=2.61u as=0.2249p ps=1.385u w=0.865u l=0.5u
X13 a_8721_n336# a_6921_n20# a_7781_n69# VPW nfet_05v0 ad=0.2007p pd=1.475u as=0.2007p ps=1.475u w=0.36u l=0.6u
X14 a_10142_n423# a_9138_n380# VDD VNW pfet_05v0 ad=0.5346p pd=3.31u as=0.5346p ps=3.31u w=1.215u l=0.5u
X15 a_6921_n20# a_6509_n341# VSS VPW nfet_05v0 ad=0.1782p pd=1.69u as=0.1053p ps=0.925u w=0.405u l=0.6u
X16 a_7269_n20# MODE VSS VPW nfet_05v0 ad=93.59999f pd=0.88u as=0.1584p ps=1.6u w=0.36u l=0.6u
X17 a_9138_n380# RN VDD VNW pfet_05v0 ad=0.26p pd=1.52u as=0.29465p ps=1.74u w=1u l=0.5u
X18 a_7677_n20# RN VDD VNW pfet_05v0 ad=0.3432p pd=2.44u as=0.45p ps=2.02u w=0.78u l=0.5u
X19 VSS CLK a_6509_n341# VPW nfet_05v0 ad=0.1053p pd=0.925u as=0.1782p ps=1.69u w=0.405u l=0.6u
X20 a_9514_n336# RN VSS VPW nfet_05v0 ad=0.134p pd=1.1u as=0.1224p ps=1.04u w=0.36u l=0.6u
X21 a_7269_n20# MODE VDD VNW pfet_05v0 ad=0.2028p pd=1.3u as=0.3432p ps=2.44u w=0.78u l=0.5u
X22 a_10142_n423# a_9138_n380# VSS VPW nfet_05v0 ad=0.3586p pd=2.51u as=0.3586p ps=2.51u w=0.815u l=0.6u
X23 a_7473_n20# a_6921_n20# a_7269_n20# VNW pfet_05v0 ad=0.2028p pd=1.3u as=0.2028p ps=1.3u w=0.78u l=0.5u
X24 a_7781_n69# a_7473_n20# VDD VNW pfet_05v0 ad=0.2424p pd=1.465u as=0.2222p ps=1.89u w=0.505u l=0.5u
X25 a_8721_n336# a_6509_n341# a_7781_n69# VNW pfet_05v0 ad=0.25375p pd=1.51u as=0.2424p ps=1.465u w=0.505u l=0.5u
X26 a_7677_n20# a_6509_n341# a_7473_n20# VNW pfet_05v0 ad=0.2028p pd=1.3u as=0.2028p ps=1.3u w=0.78u l=0.5u
X27 VSS a_9138_n380# a_9033_n336# VPW nfet_05v0 ad=0.1224p pd=1.04u as=94.5f ps=0.885u w=0.36u l=0.6u
C0 a_7781_n69# a_6921_n20# 0.8821f
C1 VSS VDD 0.01338f
C2 a_9033_n336# a_8721_n336# 0.11969f
C3 a_7677_n20# a_6509_n341# 0.007f
C4 a_7677_n20# VNW 0.01627f
C5 a_7761_n336# a_6921_n20# 0.00207f
C6 a_7473_n20# a_7269_n20# 0.04844f
C7 a_9138_n380# a_10142_n423# 0.10944f
C8 MODE a_6509_n341# 0.09411f
C9 MODE VNW 0.12823f
C10 a_7781_n69# a_7677_n20# 0.02667f
C11 a_9033_n336# a_9138_n380# 0.11606f
C12 VSS a_8721_n336# 0.03047f
C13 a_6921_n20# a_7269_n20# 0.40164f
C14 a_9033_n336# a_6921_n20# 0.27749f
C15 VSS a_7929_n336# 0.0019f
C16 VSS a_7473_n20# 0.04356f
C17 RN a_6509_n341# 0.0801f
C18 RN VNW 0.32949f
C19 VSS a_9138_n380# 0.185f
C20 VSS a_6921_n20# 1.20207f
C21 a_7781_n69# RN 0.07929f
C22 MODE a_7269_n20# 0.08286f
C23 CLK a_6509_n341# 0.6696f
C24 VDD a_8721_n336# 1.11667f
C25 CLK VNW 0.13704f
C26 VDD a_7473_n20# 0.11921f
C27 RN a_10142_n423# 0
C28 VNW a_6509_n341# 1.28833f
C29 VSS MODE 0.06462f
C30 VDD a_9138_n380# 0.10205f
C31 a_7781_n69# a_6509_n341# 0.05539f
C32 a_7781_n69# VNW 0.14901f
C33 a_9033_n336# RN 0.03878f
C34 VDD a_6921_n20# 0.45627f
C35 a_7473_n20# a_8721_n336# 0.00123f
C36 a_6509_n341# a_10142_n423# 0
C37 a_7929_n336# a_7473_n20# 0
C38 VNW a_10142_n423# 0.03444f
C39 VDD a_7677_n20# 0.28263f
C40 VSS RN 0.44197f
C41 a_9138_n380# a_8721_n336# 0.63332f
C42 a_6509_n341# a_7269_n20# 0.01185f
C43 VNW a_7269_n20# 0.01023f
C44 a_8721_n336# a_6921_n20# 0.51037f
C45 VDD MODE 0.00937f
C46 a_9033_n336# a_6509_n341# 0.00367f
C47 a_9033_n336# VNW 0.02016f
C48 a_7929_n336# a_6921_n20# 0.00227f
C49 a_7473_n20# a_6921_n20# 0.36196f
C50 VSS CLK 0.02195f
C51 a_9138_n380# a_6921_n20# 0.02046f
C52 VSS a_6509_n341# 0.29126f
C53 a_9138_n380# a_9514_n336# 0.00177f
C54 VSS VNW 0.0106f
C55 a_7677_n20# a_7473_n20# 0.66083f
C56 VDD RN 0.03498f
C57 VSS a_7781_n69# 0.01387f
C58 MODE a_7473_n20# 0
C59 VSS a_7761_n336# 0.0017f
C60 a_7677_n20# a_6921_n20# 0.009f
C61 CLK VDD 0.02303f
C62 VSS a_10142_n423# 0.1134f
C63 MODE a_6921_n20# 0.32879f
C64 RN a_8721_n336# 0.09434f
C65 VDD a_6509_n341# 0.41709f
C66 VDD VNW 0.50356f
C67 RN a_7473_n20# 0.0832f
C68 VSS a_7269_n20# 0.05215f
C69 VSS a_9033_n336# 0.1285f
C70 VDD a_7781_n69# 0.09419f
C71 a_9138_n380# RN 0.33647f
C72 RN a_6921_n20# 0.07873f
C73 RN a_9514_n336# 0.01068f
C74 a_8721_n336# a_6509_n341# 0.0428f
C75 VNW a_8721_n336# 0.21243f
C76 VDD a_10142_n423# 0.14934f
C77 a_7473_n20# a_6509_n341# 0.08126f
C78 a_7473_n20# VNW 0.24136f
C79 a_7781_n69# a_8721_n336# 0.05672f
C80 RN a_7677_n20# 0.02104f
C81 VDD a_7269_n20# 0
C82 CLK a_6921_n20# 0.00276f
C83 VDD a_9033_n336# 0.00217f
C84 a_7781_n69# a_7473_n20# 0.93419f
C85 a_9138_n380# a_6509_n341# 0.01904f
C86 a_9138_n380# VNW 0.35472f
C87 a_6509_n341# a_6921_n20# 0.53697f
C88 VNW a_6921_n20# 0.34128f
C89 a_7761_n336# a_7473_n20# 0
C90 a_8721_n336# a_10142_n423# 0.01436f
C91 VSS VPW 1.26186f
C92 RN VPW 1.36673f
C93 MODE VPW 0.25341f
C94 VDD VPW 0.79945f
C95 CLK VPW 0.29124f
C96 VNW VPW 6.1377f
C97 a_10142_n423# VPW 0.11476f
C98 a_9033_n336# VPW 0.01697f
C99 a_9138_n380# VPW 0.62251f
C100 a_8721_n336# VPW 0.37166f
C101 a_7677_n20# VPW 0.01297f
C102 a_7473_n20# VPW 0.29173f
C103 a_7269_n20# VPW 0.02321f
C104 a_7781_n69# VPW 0.27904f
C105 a_6921_n20# VPW 0.68441f
C106 a_6509_n341# VPW 1.43589f
.ends

.subckt MODE+FSM MODE_Q
Xdffsnq_0 nor2_0/A2 dffrnq_0/RN dffsnq_0/CLK or2_0/VNW or2_0/VPW dffsnq_0/a_1836_282#
+ m2_3305_n910# dffsnq_0/a_1492_238# dffsnq_0/a_3220_277# dffsnq_0/a_1179_653# dffsnq_0/a_975_282#
+ dffsnq_0/a_175_277# dffsnq_0/a_587_598# or2_0/VPW dffsnq_0/a_1432_653# dffsnq_0/a_2588_282#
+ dffsnq_0/a_2364_282# dffsnq_0/a_3268_233# or2_0/VNW dffsnq_0/a_1423_282# dffsnq
Xor2_0 or2_0/MODE_Q2 or2_0/VNW or2_0/VPW or2_0/a_n505_n1653# m2_3305_n910# or2_0/VPW
+ dffrnq_0/S1 or2_0/a_n317_n1653# or2_0/VNW or2
Xnor2_0 dffrnq_0/S1 nor2_0/TREAT_EN nor2_0/A2 or2_0/VPW or2_0/VNW or2_0/VNW nor2_0/a_1490_n1804#
+ or2_0/VPW nor2
Xdffrnq_0 dffrnq_0/S1 dffrnq_0/RN dffsnq_0/CLK or2_0/VNW or2_0/VPW dffrnq_0/a_1002_n2102#
+ dffrnq_0/a_1458_n1702# dffrnq_0/a_2250_n1702# dffrnq_0/a_2667_n1842# dffrnq_0/a_38_n1706#
+ dffrnq_0/a_798_n2102# m2_3239_n1773# dffrnq_0/a_450_n2119# dffrnq_0/a_1310_n2146#
+ or2_0/VNW or2_0/VPW dffrnq_0/a_1206_n2102# dffrnq_0/a_1290_n1702# dffrnq_0/a_2562_n1702#
+ dffrnq_0/a_3043_n1702# dffrnq
XMODEdffrnq1_0 dffrnq_0/RN or2_0/VPW dffsnq_0/CLK or2_0/VNW or2_0/VNW or2_0/VPW MODEdffrnq1_0/a_9844_4849#
+ MODEdffrnq1_0/a_8007_5165# MODEdffrnq1_0/a_8259_4849# MODEdffrnq1_0/a_7251_5165#
+ MODEdffrnq1_0/a_8111_5116# MODEdffrnq1_0/a_9363_4849# MODEdffrnq1_0/a_6839_4844#
+ MODEdffrnq1_0/a_9468_4805# MODEdffrnq1_0/a_7599_5165# MODEdffrnq1_0/a_8091_4849#
+ MODEdffrnq1_0/a_9051_4849# or2_0/MODE_Q2 MODEdffrnq1_0/a_7803_5165# MODE_Q MODEdffrnq1
Xand2_0 or2_0/VNW or2_0/VPW or2_0/MODE_Q2 or2_0/VNW or2_0/VPW and2_0/a_3366_935# and2_0/a_3574_935#
+ nor2_0/A2 m2_3239_n1773# and2
XMODEdffrnq0_0 or2_0/VNW dffsnq_0/CLK or2_0/VPW dffrnq_0/RN MODEdffrnq0_0/MODE or2_0/VNW
+ or2_0/VPW MODEdffrnq0_0/a_7269_n20# MODEdffrnq0_0/a_7929_n336# MODE_Q MODEdffrnq0_0/a_7781_n69#
+ MODEdffrnq0_0/a_6509_n341# MODEdffrnq0_0/a_7761_n336# MODEdffrnq0_0/a_8721_n336#
+ MODEdffrnq0_0/a_9514_n336# MODEdffrnq0_0/a_7677_n20# MODEdffrnq0_0/a_7473_n20# MODEdffrnq0_0/a_6921_n20#
+ MODEdffrnq0_0/a_9033_n336# MODEdffrnq0_0/a_9138_n380# MODEdffrnq0
C0 dffrnq_0/a_450_n2119# dffsnq_0/a_175_277# 0
C1 dffrnq_0/S1 dffrnq_0/a_3043_n1702# 0
C2 MODEdffrnq1_0/a_6839_4844# or2_0/MODE_Q2 0.07365f
C3 or2_0/MODE_Q2 dffsnq_0/a_1836_282# 0
C4 MODEdffrnq1_0/a_9051_4849# MODE_Q 0.07898f
C5 MODEdffrnq0_0/a_7929_n336# MODE_Q 0
C6 MODEdffrnq1_0/a_7599_5165# or2_0/VNW -0
C7 nor2_0/A2 dffrnq_0/RN 0.03746f
C8 MODEdffrnq0_0/a_8721_n336# MODEdffrnq1_0/a_9468_4805# 0
C9 MODEdffrnq1_0/a_9468_4805# or2_0/MODE_Q2 0.03494f
C10 dffsnq_0/a_587_598# dffrnq_0/a_38_n1706# 0
C11 dffrnq_0/S1 dffsnq_0/a_2364_282# 0.01621f
C12 MODEdffrnq0_0/a_6921_n20# MODEdffrnq1_0/a_7251_5165# 0.00489f
C13 MODEdffrnq1_0/a_9363_4849# dffrnq_0/RN 0
C14 dffrnq_0/S1 and2_0/a_3574_935# 0.00105f
C15 MODEdffrnq0_0/a_6509_n341# MODEdffrnq1_0/a_8007_5165# 0
C16 dffrnq_0/a_1310_n2146# or2_0/VNW 0
C17 dffrnq_0/S1 MODEdffrnq1_0/a_6839_4844# 0
C18 dffrnq_0/S1 dffsnq_0/a_1836_282# 0
C19 m2_3305_n910# or2_0/VNW 0.07267f
C20 MODEdffrnq0_0/a_6509_n341# or2_0/MODE_Q2 0.00367f
C21 MODEdffrnq1_0/a_7251_5165# dffrnq_0/RN 0.00397f
C22 MODEdffrnq1_0/a_6839_4844# dffsnq_0/a_175_277# 0.05482f
C23 dffrnq_0/RN dffsnq_0/a_3268_233# 0
C24 dffrnq_0/S1 MODEdffrnq1_0/a_9468_4805# 0
C25 or2_0/MODE_Q2 dffsnq_0/a_1432_653# 0
C26 or2_0/MODE_Q2 MODEdffrnq0_0/MODE 0
C27 MODEdffrnq1_0/a_6839_4844# dffrnq_0/a_1002_n2102# 0
C28 nor2_0/A2 or2_0/MODE_Q2 0.04189f
C29 MODEdffrnq0_0/a_9138_n380# or2_0/VNW 0.00693f
C30 dffrnq_0/a_2250_n1702# dffsnq_0/a_2364_282# 0
C31 dffrnq_0/a_798_n2102# nor2_0/A2 0.02803f
C32 dffrnq_0/a_1206_n2102# dffsnq_0/a_175_277# 0
C33 nor2_0/A2 dffsnq_0/a_3220_277# 0
C34 MODEdffrnq0_0/a_7473_n20# or2_0/VNW 0
C35 MODE_Q MODEdffrnq1_0/a_7803_5165# 0.11914f
C36 MODEdffrnq1_0/a_9363_4849# or2_0/MODE_Q2 0.01008f
C37 dffrnq_0/S1 nor2_0/a_1490_n1804# 0.00313f
C38 dffsnq_0/a_1492_238# dffrnq_0/RN 0
C39 MODEdffrnq0_0/a_7781_n69# MODEdffrnq1_0/a_8111_5116# 0.00376f
C40 nor2_0/A2 or2_0/a_n505_n1653# 0
C41 dffsnq_0/CLK dffrnq_0/RN 0.00354f
C42 dffrnq_0/S1 dffsnq_0/a_1432_653# 0
C43 or2_0/MODE_Q2 MODEdffrnq1_0/a_7251_5165# 0.08604f
C44 or2_0/MODE_Q2 dffsnq_0/a_3268_233# 0.00979f
C45 dffrnq_0/a_2667_n1842# or2_0/MODE_Q2 0
C46 dffrnq_0/S1 nor2_0/A2 0.80131f
C47 nor2_0/A2 dffsnq_0/a_2588_282# 0
C48 dffrnq_0/a_450_n2119# or2_0/VNW -0
C49 MODEdffrnq0_0/a_9033_n336# or2_0/VNW 0
C50 nor2_0/A2 m2_3239_n1773# 0.45662f
C51 nor2_0/A2 dffsnq_0/a_175_277# 0
C52 MODEdffrnq1_0/a_9051_4849# dffrnq_0/RN 0.00208f
C53 MODEdffrnq0_0/a_6509_n341# MODEdffrnq1_0/a_8111_5116# 0
C54 MODEdffrnq0_0/a_6921_n20# MODE_Q 0.00992f
C55 dffrnq_0/a_38_n1706# or2_0/MODE_Q2 0
C56 or2_0/MODE_Q2 dffsnq_0/a_1492_238# 0.01053f
C57 nor2_0/A2 dffrnq_0/a_1002_n2102# 0.12522f
C58 or2_0/MODE_Q2 and2_0/a_3366_935# 0.00768f
C59 dffsnq_0/CLK or2_0/MODE_Q2 0.03385f
C60 dffrnq_0/S1 dffsnq_0/a_3268_233# 0.00916f
C61 dffrnq_0/S1 dffrnq_0/a_2667_n1842# 0.04664f
C62 dffrnq_0/a_2250_n1702# nor2_0/A2 0.10297f
C63 nor2_0/A2 nor2_0/TREAT_EN 0.02181f
C64 or2_0/a_n505_n1653# and2_0/a_3366_935# 0.0036f
C65 MODE_Q dffrnq_0/RN 0.07008f
C66 dffrnq_0/a_1310_n2146# MODEdffrnq1_0/a_6839_4844# 0
C67 or2_0/VNW dffsnq_0/a_2364_282# 0.01412f
C68 dffrnq_0/RN dffsnq_0/a_1179_653# 0.00638f
C69 dffsnq_0/CLK or2_0/a_n505_n1653# 0.01351f
C70 m2_3305_n910# MODEdffrnq1_0/a_6839_4844# 0
C71 MODEdffrnq0_0/a_6921_n20# MODEdffrnq1_0/a_7803_5165# 0
C72 MODEdffrnq0_0/a_7269_n20# MODE_Q 0.00129f
C73 MODEdffrnq0_0/a_9138_n380# dffsnq_0/a_2364_282# 0
C74 dffrnq_0/S1 dffsnq_0/a_1492_238# 0.01008f
C75 dffrnq_0/S1 dffrnq_0/a_38_n1706# 0.04348f
C76 MODEdffrnq0_0/a_8721_n336# MODEdffrnq1_0/a_9051_4849# 0.00664f
C77 MODEdffrnq1_0/a_9051_4849# or2_0/MODE_Q2 0.13399f
C78 dffrnq_0/S1 and2_0/a_3366_935# 0.06825f
C79 MODEdffrnq1_0/a_6839_4844# or2_0/VNW 0.172f
C80 dffrnq_0/S1 dffsnq_0/CLK 0.01441f
C81 MODE_Q MODEdffrnq1_0/a_8007_5165# 0.02179f
C82 dffrnq_0/a_38_n1706# m2_3239_n1773# 0.13668f
C83 m2_3239_n1773# and2_0/a_3366_935# 0.00515f
C84 dffrnq_0/a_38_n1706# dffsnq_0/a_175_277# 0.03768f
C85 dffsnq_0/CLK m2_3239_n1773# 0.04562f
C86 dffrnq_0/a_2250_n1702# dffsnq_0/a_3268_233# 0.00269f
C87 MODEdffrnq0_0/a_7473_n20# MODEdffrnq1_0/a_6839_4844# 0
C88 dffrnq_0/a_1002_n2102# dffsnq_0/a_1492_238# 0
C89 MODEdffrnq1_0/a_9468_4805# or2_0/VNW 0.02173f
C90 MODEdffrnq0_0/a_7781_n69# or2_0/VNW 0
C91 dffsnq_0/CLK dffsnq_0/a_175_277# 0.02184f
C92 MODEdffrnq0_0/a_9138_n380# MODEdffrnq1_0/a_9468_4805# 0.00634f
C93 MODEdffrnq0_0/a_8721_n336# MODE_Q 0.00804f
C94 MODE_Q or2_0/MODE_Q2 0.73774f
C95 or2_0/MODE_Q2 dffsnq_0/a_1179_653# 0.00815f
C96 dffsnq_0/a_587_598# dffrnq_0/RN 0.04556f
C97 dffrnq_0/S1 MODEdffrnq1_0/a_9051_4849# 0
C98 nor2_0/a_1490_n1804# or2_0/VNW 0
C99 or2_0/a_n317_n1653# or2_0/MODE_Q2 0.00158f
C100 dffrnq_0/S1 dffrnq_0/a_1290_n1702# 0
C101 nor2_0/TREAT_EN and2_0/a_3366_935# 0.0089f
C102 dffrnq_0/a_1310_n2146# nor2_0/A2 0.08139f
C103 dffsnq_0/CLK nor2_0/TREAT_EN 0
C104 MODEdffrnq1_0/a_6839_4844# dffrnq_0/a_450_n2119# 0
C105 MODEdffrnq0_0/a_6509_n341# or2_0/VNW 0.03592f
C106 MODEdffrnq1_0/a_7599_5165# MODEdffrnq1_0/a_7251_5165# -0
C107 or2_0/VNW MODEdffrnq0_0/MODE 0
C108 MODEdffrnq0_0/a_9514_n336# MODE_Q 0
C109 MODEdffrnq1_0/a_7803_5165# or2_0/MODE_Q2 0.04066f
C110 nor2_0/A2 or2_0/VNW 0.43724f
C111 dffrnq_0/S1 dffsnq_0/a_1179_653# 0.00787f
C112 MODEdffrnq1_0/a_9363_4849# or2_0/VNW -0
C113 dffrnq_0/a_2250_n1702# MODEdffrnq1_0/a_9051_4849# 0
C114 dffrnq_0/S1 or2_0/a_n317_n1653# 0
C115 dffsnq_0/a_587_598# or2_0/MODE_Q2 0.01795f
C116 dffrnq_0/S1 dffrnq_0/a_2562_n1702# 0.02552f
C117 MODEdffrnq1_0/a_8111_5116# MODE_Q 0.10551f
C118 or2_0/VNW MODEdffrnq1_0/a_7251_5165# 0.00303f
C119 dffrnq_0/a_2667_n1842# or2_0/VNW 0.00896f
C120 or2_0/VNW dffsnq_0/a_3268_233# 0.02164f
C121 dffrnq_0/a_1310_n2146# dffsnq_0/a_1492_238# 0.00298f
C122 MODEdffrnq0_0/a_6921_n20# or2_0/MODE_Q2 0
C123 MODEdffrnq0_0/a_9138_n380# dffsnq_0/a_3268_233# 0
C124 dffrnq_0/a_38_n1706# m2_3305_n910# 0
C125 m2_3305_n910# dffsnq_0/a_1492_238# 0
C126 MODEdffrnq1_0/a_9468_4805# dffsnq_0/a_2364_282# 0
C127 nor2_0/A2 dffrnq_0/a_450_n2119# 0.13606f
C128 MODEdffrnq0_0/a_7473_n20# MODEdffrnq1_0/a_7251_5165# 0
C129 dffrnq_0/S1 dffsnq_0/a_587_598# 0.02152f
C130 dffsnq_0/CLK m2_3305_n910# 0.08424f
C131 dffrnq_0/a_38_n1706# or2_0/VNW 0.00185f
C132 or2_0/VNW dffsnq_0/a_1492_238# 0.00392f
C133 or2_0/VNW and2_0/a_3366_935# -0.00916f
C134 MODEdffrnq0_0/a_7677_n20# or2_0/VNW -0
C135 dffrnq_0/a_3043_n1702# nor2_0/A2 0
C136 MODEdffrnq0_0/a_7781_n69# MODEdffrnq1_0/a_6839_4844# 0
C137 dffsnq_0/CLK or2_0/VNW 0.32262f
C138 dffsnq_0/a_587_598# dffsnq_0/a_175_277# -0
C139 MODE_Q MODEdffrnq1_0/a_8091_4849# 0
C140 or2_0/MODE_Q2 dffrnq_0/RN 0.02365f
C141 dffrnq_0/S1 dffrnq_0/a_1458_n1702# 0
C142 dffsnq_0/a_587_598# dffrnq_0/a_1002_n2102# 0
C143 MODE_Q MODEdffrnq1_0/a_7599_5165# 0.03015f
C144 nor2_0/A2 dffsnq_0/a_2364_282# 0.00366f
C145 or2_0/MODE_Q2 MODEdffrnq1_0/a_8007_5165# 0.05069f
C146 MODEdffrnq1_0/a_9051_4849# or2_0/VNW 0.01044f
C147 MODEdffrnq0_0/a_6509_n341# MODEdffrnq1_0/a_6839_4844# 0.03784f
C148 and2_0/a_3574_935# nor2_0/A2 0
C149 or2_0/MODE_Q2 dffsnq_0/a_1423_282# 0
C150 MODEdffrnq0_0/a_9138_n380# MODEdffrnq1_0/a_9051_4849# 0
C151 dffrnq_0/a_450_n2119# dffsnq_0/a_1492_238# 0
C152 MODEdffrnq0_0/a_6921_n20# MODEdffrnq1_0/a_8111_5116# 0
C153 nor2_0/A2 MODEdffrnq1_0/a_6839_4844# 0
C154 dffrnq_0/S1 dffrnq_0/RN 0.08294f
C155 dffsnq_0/a_975_282# dffsnq_0/a_587_598# -0
C156 dffsnq_0/a_2588_282# dffrnq_0/RN 0.00129f
C157 dffrnq_0/a_1310_n2146# dffsnq_0/a_1179_653# 0
C158 dffrnq_0/a_798_n2102# or2_0/MODE_Q2 0
C159 m2_3239_n1773# dffrnq_0/RN 0
C160 m2_3305_n910# dffsnq_0/a_1179_653# 0.00217f
C161 nor2_0/A2 dffrnq_0/a_1206_n2102# 0.03411f
C162 or2_0/MODE_Q2 dffsnq_0/a_3220_277# 0
C163 dffrnq_0/RN dffsnq_0/a_175_277# 0.00151f
C164 MODE_Q or2_0/VNW 0.17097f
C165 dffrnq_0/a_2667_n1842# dffsnq_0/a_2364_282# 0
C166 or2_0/VNW dffsnq_0/a_1179_653# 0.00524f
C167 MODEdffrnq0_0/a_9138_n380# MODE_Q 0.01304f
C168 or2_0/MODE_Q2 or2_0/a_n505_n1653# 0.01956f
C169 dffrnq_0/S1 dffsnq_0/a_1423_282# 0
C170 or2_0/a_n317_n1653# or2_0/VNW 0
C171 MODEdffrnq0_0/a_7473_n20# MODE_Q 0.00464f
C172 nor2_0/a_1490_n1804# nor2_0/A2 0
C173 dffrnq_0/a_2562_n1702# or2_0/VNW -0
C174 dffrnq_0/S1 or2_0/MODE_Q2 0.14804f
C175 or2_0/MODE_Q2 dffsnq_0/a_2588_282# 0.00588f
C176 dffrnq_0/S1 dffrnq_0/a_798_n2102# 0.01189f
C177 dffrnq_0/S1 dffsnq_0/a_3220_277# 0
C178 MODEdffrnq0_0/a_7781_n69# MODEdffrnq1_0/a_7251_5165# 0
C179 MODEdffrnq1_0/a_9468_4805# dffsnq_0/a_3268_233# 0.00116f
C180 dffsnq_0/a_587_598# dffrnq_0/a_1310_n2146# 0
C181 dffrnq_0/a_2667_n1842# MODEdffrnq1_0/a_9468_4805# 0.0011f
C182 MODEdffrnq1_0/a_7803_5165# or2_0/VNW 0
C183 m2_3239_n1773# or2_0/MODE_Q2 0.00159f
C184 MODE_Q MODEdffrnq1_0/a_8259_4849# 0
C185 MODEdffrnq1_0/a_6839_4844# dffsnq_0/a_1492_238# 0.00507f
C186 dffsnq_0/a_587_598# m2_3305_n910# 0.03797f
C187 dffrnq_0/a_798_n2102# m2_3239_n1773# 0.02259f
C188 or2_0/MODE_Q2 dffsnq_0/a_175_277# 0.02368f
C189 MODEdffrnq0_0/a_7677_n20# MODEdffrnq1_0/a_6839_4844# 0
C190 dffrnq_0/S1 or2_0/a_n505_n1653# 0.03149f
C191 dffsnq_0/CLK MODEdffrnq1_0/a_6839_4844# 0.0219f
C192 dffrnq_0/a_1002_n2102# or2_0/MODE_Q2 0
C193 dffrnq_0/a_450_n2119# dffsnq_0/a_1179_653# 0
C194 MODEdffrnq0_0/a_9033_n336# MODE_Q 0.00188f
C195 dffrnq_0/a_1206_n2102# dffsnq_0/a_1492_238# 0
C196 dffsnq_0/a_587_598# or2_0/VNW -0
C197 MODEdffrnq1_0/a_8111_5116# or2_0/MODE_Q2 0.02725f
C198 MODEdffrnq1_0/a_9844_4849# MODE_Q 0
C199 m2_3239_n1773# or2_0/a_n505_n1653# 0.00108f
C200 MODEdffrnq1_0/a_9051_4849# dffsnq_0/a_2364_282# 0
C201 or2_0/a_n505_n1653# dffsnq_0/a_175_277# 0
C202 MODEdffrnq0_0/a_6509_n341# MODEdffrnq1_0/a_7251_5165# 0
C203 dffrnq_0/S1 dffsnq_0/a_2588_282# 0.00622f
C204 dffrnq_0/a_2250_n1702# or2_0/MODE_Q2 0
C205 dffrnq_0/S1 m2_3239_n1773# 0.3421f
C206 nor2_0/A2 dffsnq_0/a_3268_233# 0.0078f
C207 MODEdffrnq0_0/a_6921_n20# or2_0/VNW 0
C208 dffrnq_0/a_2667_n1842# nor2_0/A2 0.11643f
C209 dffrnq_0/S1 dffsnq_0/a_175_277# 0.01819f
C210 dffsnq_0/a_975_282# or2_0/MODE_Q2 0.00277f
C211 dffrnq_0/S1 dffrnq_0/a_1002_n2102# 0.01893f
C212 MODE_Q dffsnq_0/a_2364_282# 0
C213 m2_3305_n910# dffrnq_0/RN 0
C214 m2_3239_n1773# dffrnq_0/a_1002_n2102# 0
C215 dffsnq_0/CLK MODEdffrnq0_0/a_6509_n341# 0.01222f
C216 dffsnq_0/a_587_598# dffrnq_0/a_450_n2119# 0.00481f
C217 nor2_0/A2 dffsnq_0/a_1492_238# 0
C218 dffrnq_0/a_38_n1706# nor2_0/A2 0.0792f
C219 dffrnq_0/a_1002_n2102# dffsnq_0/a_175_277# 0
C220 nor2_0/A2 and2_0/a_3366_935# 0.10792f
C221 dffrnq_0/S1 dffrnq_0/a_2250_n1702# 0.02201f
C222 or2_0/VNW dffrnq_0/RN 0.34591f
C223 MODE_Q MODEdffrnq1_0/a_6839_4844# 0.02205f
C224 dffrnq_0/S1 nor2_0/TREAT_EN 0.03989f
C225 dffsnq_0/CLK nor2_0/A2 0.0401f
C226 MODEdffrnq1_0/a_7599_5165# or2_0/MODE_Q2 0.00629f
C227 MODEdffrnq1_0/a_6839_4844# dffsnq_0/a_1179_653# 0.0046f
C228 dffrnq_0/a_2667_n1842# dffsnq_0/a_3268_233# 0.0011f
C229 m2_3239_n1773# nor2_0/TREAT_EN 0
C230 dffsnq_0/a_975_282# dffrnq_0/S1 0.00273f
C231 MODEdffrnq1_0/a_9468_4805# MODE_Q 0.13341f
C232 MODEdffrnq0_0/a_7781_n69# MODE_Q 0.00557f
C233 or2_0/VNW MODEdffrnq1_0/a_8007_5165# -0
C234 m2_3305_n910# or2_0/MODE_Q2 0.06743f
C235 nor2_0/A2 dffrnq_0/a_1290_n1702# 0
C236 MODEdffrnq0_0/a_8721_n336# or2_0/VNW 0
C237 or2_0/MODE_Q2 or2_0/VNW 1.23828f
C238 dffrnq_0/a_798_n2102# or2_0/VNW -0
C239 MODEdffrnq0_0/a_6509_n341# MODE_Q 0.00626f
C240 dffrnq_0/a_38_n1706# dffsnq_0/a_1492_238# 0
C241 dffsnq_0/a_587_598# MODEdffrnq1_0/a_6839_4844# 0
C242 m2_3305_n910# or2_0/a_n505_n1653# 0.00284f
C243 MODEdffrnq0_0/a_7781_n69# MODEdffrnq1_0/a_7803_5165# 0
C244 dffrnq_0/a_38_n1706# and2_0/a_3366_935# 0.00138f
C245 MODE_Q MODEdffrnq0_0/MODE 0.00282f
C246 dffsnq_0/CLK dffrnq_0/a_38_n1706# 0.01222f
C247 dffsnq_0/CLK and2_0/a_3366_935# 0.01029f
C248 dffrnq_0/S1 dffrnq_0/a_1310_n2146# 0.03455f
C249 or2_0/VNW or2_0/a_n505_n1653# 0.03377f
C250 MODEdffrnq1_0/a_9051_4849# dffsnq_0/a_3268_233# 0.00216f
C251 MODEdffrnq1_0/a_9051_4849# dffrnq_0/a_2667_n1842# 0
C252 dffrnq_0/S1 m2_3305_n910# 0.0677f
C253 MODE_Q MODEdffrnq1_0/a_9363_4849# 0.04222f
C254 dffrnq_0/a_1310_n2146# m2_3239_n1773# 0
C255 MODEdffrnq0_0/a_7761_n336# MODE_Q 0
C256 MODEdffrnq0_0/a_6921_n20# MODEdffrnq1_0/a_6839_4844# 0
C257 dffrnq_0/a_1310_n2146# dffsnq_0/a_175_277# 0
C258 m2_3239_n1773# m2_3305_n910# 0
C259 dffrnq_0/S1 or2_0/VNW 0.26384f
C260 m2_3305_n910# dffsnq_0/a_175_277# 0.18381f
C261 or2_0/VNW dffsnq_0/a_2588_282# -0
C262 dffrnq_0/a_2562_n1702# nor2_0/A2 0.0365f
C263 MODEdffrnq0_0/a_6509_n341# MODEdffrnq1_0/a_7803_5165# 0
C264 dffrnq_0/RN dffsnq_0/a_2364_282# 0
C265 dffrnq_0/a_450_n2119# or2_0/MODE_Q2 0
C266 m2_3239_n1773# or2_0/VNW 0.00785f
C267 dffrnq_0/a_798_n2102# dffrnq_0/a_450_n2119# -0.01121f
C268 MODE_Q MODEdffrnq1_0/a_7251_5165# 0.11652f
C269 or2_0/VNW dffsnq_0/a_175_277# 0.05644f
C270 dffrnq_0/a_2667_n1842# MODE_Q 0
C271 MODE_Q dffsnq_0/a_3268_233# 0
C272 dffrnq_0/a_1002_n2102# or2_0/VNW -0
C273 MODEdffrnq1_0/a_6839_4844# dffrnq_0/RN 0.0331f
C274 MODEdffrnq1_0/a_8111_5116# or2_0/VNW 0
C275 dffsnq_0/a_587_598# nor2_0/A2 0
C276 dffrnq_0/a_2250_n1702# or2_0/VNW 0.00135f
C277 MODEdffrnq0_0/a_7677_n20# MODE_Q 0.00148f
C278 dffrnq_0/a_38_n1706# dffsnq_0/a_1179_653# 0
C279 MODEdffrnq0_0/a_7473_n20# MODEdffrnq1_0/a_8111_5116# 0
C280 MODEdffrnq1_0/a_9468_4805# dffrnq_0/RN 0.00618f
C281 dffsnq_0/a_975_282# m2_3305_n910# 0.00259f
C282 or2_0/VNW nor2_0/TREAT_EN 0.0116f
C283 dffsnq_0/CLK MODE_Q 0.00182f
C284 dffrnq_0/S1 dffrnq_0/a_450_n2119# 0.16798f
C285 nor2_0/A2 dffrnq_0/a_1458_n1702# 0
C286 or2_0/MODE_Q2 dffsnq_0/a_2364_282# 0.01047f
C287 dffsnq_0/a_975_282# or2_0/VNW -0
C288 m2_3239_n1773# dffrnq_0/a_450_n2119# 0.07464f
C289 nor2_0/A2 or2_0/VPW 1.66122f
C290 m2_3239_n1773# or2_0/VPW 0.34956f
C291 m2_3305_n910# or2_0/VPW 0.33866f
C292 MODE_Q or2_0/VPW 1.02207f
C293 dffsnq_0/CLK or2_0/VPW 1.75013f
C294 dffrnq_0/S1 or2_0/VPW 2.38205f
C295 MODEdffrnq0_0/MODE or2_0/VPW 0.25341f
C296 MODEdffrnq0_0/a_9033_n336# or2_0/VPW 0.01697f
C297 MODEdffrnq0_0/a_9138_n380# or2_0/VPW 0.62833f
C298 MODEdffrnq0_0/a_8721_n336# or2_0/VPW 0.37493f
C299 MODEdffrnq0_0/a_7677_n20# or2_0/VPW 0.01297f
C300 MODEdffrnq0_0/a_7473_n20# or2_0/VPW 0.29173f
C301 MODEdffrnq0_0/a_7269_n20# or2_0/VPW 0.02321f
C302 MODEdffrnq0_0/a_7781_n69# or2_0/VPW 0.28147f
C303 MODEdffrnq0_0/a_6921_n20# or2_0/VPW 0.68749f
C304 MODEdffrnq0_0/a_6509_n341# or2_0/VPW 1.45996f
C305 and2_0/a_3366_935# or2_0/VPW 0.39003f
C306 MODEdffrnq1_0/a_9363_4849# or2_0/VPW 0.01697f
C307 MODEdffrnq1_0/a_9468_4805# or2_0/VPW 0.62936f
C308 MODEdffrnq1_0/a_9051_4849# or2_0/VPW 0.37408f
C309 MODEdffrnq1_0/a_8007_5165# or2_0/VPW 0.01297f
C310 MODEdffrnq1_0/a_7803_5165# or2_0/VPW 0.29173f
C311 MODEdffrnq1_0/a_7599_5165# or2_0/VPW 0.02321f
C312 MODEdffrnq1_0/a_8111_5116# or2_0/VPW 0.28051f
C313 MODEdffrnq1_0/a_7251_5165# or2_0/VPW 0.68629f
C314 MODEdffrnq1_0/a_6839_4844# or2_0/VPW 1.45224f
C315 dffrnq_0/a_1206_n2102# or2_0/VPW 0.01297f
C316 dffrnq_0/a_2562_n1702# or2_0/VPW 0.01697f
C317 dffrnq_0/a_2250_n1702# or2_0/VPW 0.37403f
C318 dffrnq_0/a_2667_n1842# or2_0/VPW 0.62745f
C319 dffrnq_0/a_1002_n2102# or2_0/VPW 0.29173f
C320 dffrnq_0/a_798_n2102# or2_0/VPW 0.02321f
C321 dffrnq_0/a_1310_n2146# or2_0/VPW 0.28051f
C322 dffrnq_0/a_450_n2119# or2_0/VPW 0.68629f
C323 dffrnq_0/a_38_n1706# or2_0/VPW 1.44454f
C324 nor2_0/TREAT_EN or2_0/VPW 0.05875f
C325 or2_0/MODE_Q2 or2_0/VPW 1.23645f
C326 or2_0/a_n505_n1653# or2_0/VPW 0.35261f
C327 or2_0/VNW or2_0/VPW 36.60174f
C328 dffrnq_0/RN or2_0/VPW 5.53022f
C329 dffsnq_0/a_2588_282# or2_0/VPW 0.04999f
C330 dffsnq_0/a_2364_282# or2_0/VPW 0.43936f
C331 dffsnq_0/a_3268_233# or2_0/VPW 0.59751f
C332 dffsnq_0/a_975_282# or2_0/VPW 0.01977f
C333 dffsnq_0/a_1179_653# or2_0/VPW 0.3045f
C334 dffsnq_0/a_1492_238# or2_0/VPW 0.28879f
C335 dffsnq_0/a_587_598# or2_0/VPW 1.23021f
C336 dffsnq_0/a_175_277# or2_0/VPW 1.33067f
.ends
