* Extracted by KLayout with GF180MCU LVS runset on : 18/10/2026 05:34

.SUBCKT TGATE IN OUT C CBAR SUB
M$1 OUT CBAR IN \$8 pfet_05v0 L=0.6U W=1.22U AS=1.1712P AD=1.2078P PS=4.36U
+ PD=4.42U
M$2 OUT C IN SUB nfet_05v0 L=0.6U W=0.565U AS=0.5424P AD=0.5876P PS=3.05U
+ PD=3.21U
.ENDS TGATE
