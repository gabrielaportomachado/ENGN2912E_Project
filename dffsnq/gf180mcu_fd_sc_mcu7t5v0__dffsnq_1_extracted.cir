* Extracted by KLayout with GF180MCU LVS runset on : 11/08/2026 02:35

.SUBCKT gf180mcu_fd_sc_mcu7t5v0__dffsnq_1 VSS Q CLK D SETN VDD gf180mcu_gnd
M$1 \$3 \$4 \$7 \$30 pfet_05v0 L=0.5U W=0.415U AS=0.27805P AD=0.1079P PS=2.17U
+ PD=0.935U
M$2 \$8 \$2 \$3 \$30 pfet_05v0 L=0.5U W=0.415U AS=0.1079P AD=0.1826P PS=0.935U
+ PD=1.71U
M$3 \$5 D VDD \$30 pfet_05v0 L=0.5U W=0.505U AS=0.22725P AD=0.1313P PS=1.91U
+ PD=1.025U
M$4 \$6 \$2 \$5 \$30 pfet_05v0 L=0.5U W=0.505U AS=0.1313P AD=0.1931625P
+ PS=1.025U PD=1.27U
M$5 \$24 \$4 \$6 \$30 pfet_05v0 L=0.5U W=0.505U AS=0.1931625P AD=0.101P
+ PS=1.27U PD=0.905U
M$6 VDD \$7 \$24 \$30 pfet_05v0 L=0.5U W=0.505U AS=0.101P AD=0.3975P PS=0.905U
+ PD=2.185U
M$7 \$7 \$6 VDD \$30 pfet_05v0 L=0.5U W=0.585U AS=0.3975P AD=0.1521P PS=2.185U
+ PD=1.105U
M$8 VDD SETN \$7 \$30 pfet_05v0 L=0.5U W=0.585U AS=0.1521P AD=0.4149P PS=1.105U
+ PD=2.65U
M$9 VDD CLK \$4 \$30 pfet_05v0 L=0.5U W=0.865U AS=0.3806P AD=0.2249P PS=2.61U
+ PD=1.385U
M$10 \$2 \$4 VDD \$30 pfet_05v0 L=0.5U W=0.865U AS=0.2249P AD=0.3806P PS=1.385U
+ PD=2.61U
M$11 \$8 SETN VDD \$30 pfet_05v0 L=0.5U W=0.78U AS=0.3432P AD=0.2028P PS=2.44U
+ PD=1.3U
M$12 VDD \$9 \$8 \$30 pfet_05v0 L=0.5U W=0.78U AS=0.2028P AD=0.3276P PS=1.3U
+ PD=1.62U
M$13 \$9 \$3 VDD \$30 pfet_05v0 L=0.5U W=0.78U AS=0.3276P AD=0.3432P PS=1.62U
+ PD=2.44U
M$14 Q \$9 VDD \$30 pfet_05v0 L=0.5U W=1.215U AS=0.5346P AD=0.6561P PS=3.31U
+ PD=3.51U
M$15 \$5 D VSS gf180mcu_gnd nfet_05v0 L=0.6U W=0.36U AS=0.1584P AD=0.0936P
+ PS=1.6U PD=0.88U
M$16 \$6 \$4 \$5 gf180mcu_gnd nfet_05v0 L=0.6U W=0.36U AS=0.0936P AD=0.0936P
+ PS=0.88U PD=0.88U
M$17 \$14 \$2 \$6 gf180mcu_gnd nfet_05v0 L=0.6U W=0.36U AS=0.0936P AD=0.0621P
+ PS=0.88U PD=0.705U
M$18 VSS \$7 \$14 gf180mcu_gnd nfet_05v0 L=0.6U W=0.36U AS=0.0621P AD=0.0936P
+ PS=0.705U PD=0.88U
M$19 \$16 \$6 VSS gf180mcu_gnd nfet_05v0 L=0.6U W=0.36U AS=0.0936P AD=0.0864P
+ PS=0.88U PD=0.84U
M$20 \$7 SETN \$16 gf180mcu_gnd nfet_05v0 L=0.6U W=0.36U AS=0.0864P AD=0.1989P
+ PS=0.84U PD=1.465U
M$21 \$3 \$2 \$7 gf180mcu_gnd nfet_05v0 L=0.6U W=0.36U AS=0.1989P AD=0.0936P
+ PS=1.465U PD=0.88U
M$22 \$8 \$4 \$3 gf180mcu_gnd nfet_05v0 L=0.6U W=0.36U AS=0.0936P AD=0.2898P
+ PS=0.88U PD=2.33U
M$23 VSS CLK \$4 gf180mcu_gnd nfet_05v0 L=0.6U W=0.405U AS=0.1782P AD=0.1053P
+ PS=1.69U PD=0.925U
M$24 \$2 \$4 VSS gf180mcu_gnd nfet_05v0 L=0.6U W=0.405U AS=0.1053P AD=0.1782P
+ PS=0.925U PD=1.69U
M$25 \$15 SETN \$8 gf180mcu_gnd nfet_05v0 L=0.6U W=0.405U AS=0.3123P AD=0.0486P
+ PS=2.38U PD=0.645U
M$26 VSS \$9 \$15 gf180mcu_gnd nfet_05v0 L=0.6U W=0.405U AS=0.0486P AD=0.14985P
+ PS=0.645U PD=1.145U
M$27 \$9 \$3 VSS gf180mcu_gnd nfet_05v0 L=0.6U W=0.405U AS=0.14985P AD=0.1782P
+ PS=1.145U PD=1.69U
M$28 Q \$9 VSS gf180mcu_gnd nfet_05v0 L=0.6U W=0.815U AS=0.3586P AD=0.3586P
+ PS=2.51U PD=2.51U
.ENDS gf180mcu_fd_sc_mcu7t5v0__dffsnq_1
