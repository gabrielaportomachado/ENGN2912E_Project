* NGSPICE file created from gf180mcu_fd_sc_mcu7t5v0__dffsnq_1.ext - technology: gf180mcuD

.subckt gf180mcu_fd_sc_mcu7t5v0__dffsnq_1 VSS CLK VDD D Q SETN VNW VPW
X0 VSS.t0 CLK.t0 a_36_151# VPW.t1 nfet_05v0 ad=0.1053p pd=0.925u as=0.1782p ps=1.69u w=0.405u l=0.6u
X1 a_1353_112# SETN.t0 a_1697_156# VPW.t5 nfet_05v0 ad=0.1989p pd=1.465u as=86.39999f ps=0.84u w=0.36u l=0.6u
X2 a_836_156# D.t0 VDD.t4 VNW.t8 pfet_05v0 ad=0.1313p pd=1.025u as=0.22725p ps=1.91u w=0.505u l=0.5u
X3 a_1040_527# a_36_151# a_836_156# VPW.t4 nfet_05v0 ad=93.59999f pd=0.88u as=93.59999f ps=0.88u w=0.36u l=0.6u
X4 a_1040_527# a_448_472# a_836_156# VNW.t7 pfet_05v0 ad=0.19315p pd=1.27u as=0.1313p ps=1.025u w=0.505u l=0.5u
X5 a_2225_156# a_36_151# a_1353_112# VNW.t5 pfet_05v0 ad=0.1079p pd=0.935u as=0.27805p ps=2.17u w=0.415u l=0.5u
X6 VSS.t4 a_1353_112# a_1284_156# VPW.t10 nfet_05v0 ad=93.59999f pd=0.88u as=62.1f ps=0.705u w=0.36u l=0.6u
X7 a_2225_156# a_448_472# a_1353_112# VPW.t8 nfet_05v0 ad=93.59999f pd=0.88u as=0.1989p ps=1.465u w=0.36u l=0.6u
X8 VDD.t2 CLK.t1 a_36_151# VNW.t2 pfet_05v0 ad=0.2249p pd=1.385u as=0.3806p ps=2.61u w=0.865u l=0.5u
X9 a_2449_156# a_448_472# a_2225_156# VNW.t6 pfet_05v0 ad=0.1826p pd=1.71u as=0.1079p ps=0.935u w=0.415u l=0.5u
X10 VDD.t8 a_3129_107# a_2449_156# VNW.t12 pfet_05v0 ad=0.3276p pd=1.62u as=0.2028p ps=1.3u w=0.78u l=0.5u
X11 Q.t0 a_3129_107# VSS.t6 VPW.t11 nfet_05v0 ad=0.3586p pd=2.51u as=0.3586p ps=2.51u w=0.815u l=0.6u
X12 a_448_472# a_36_151# VDD.t3 VNW.t4 pfet_05v0 ad=0.3806p pd=2.61u as=0.2249p ps=1.385u w=0.865u l=0.5u
X13 a_2449_156# SETN.t1 VDD.t0 VNW.t1 pfet_05v0 ad=0.2028p pd=1.3u as=0.3432p ps=2.44u w=0.78u l=0.5u
X14 VSS.t5 a_3129_107# a_3081_151# VPW.t0 nfet_05v0 ad=0.14985p pd=1.145u as=48.6f ps=0.645u w=0.405u l=0.6u
X15 a_836_156# D.t1 VSS.t2 VPW.t6 nfet_05v0 ad=93.59999f pd=0.88u as=0.1584p ps=1.6u w=0.36u l=0.6u
X16 a_448_472# a_36_151# VSS.t1 VPW.t3 nfet_05v0 ad=0.1782p pd=1.69u as=0.1053p ps=0.925u w=0.405u l=0.6u
X17 a_1353_112# a_1040_527# VDD.t5 VNW.t9 pfet_05v0 ad=0.1521p pd=1.105u as=0.3975p ps=2.185u w=0.585u l=0.5u
X18 a_3129_107# a_2225_156# VSS.t7 VPW.t0 nfet_05v0 ad=0.1782p pd=1.69u as=0.14985p ps=1.145u w=0.405u l=0.6u
X19 VDD.t1 SETN.t2 a_1353_112# VNW.t0 pfet_05v0 ad=0.4149p pd=2.65u as=0.1521p ps=1.105u w=0.585u l=0.5u
X20 a_1284_156# a_448_472# a_1040_527# VPW.t7 nfet_05v0 ad=62.1f pd=0.705u as=93.59999f ps=0.88u w=0.36u l=0.6u
X21 VDD.t6 a_1353_112# a_1293_527# VNW.t10 pfet_05v0 ad=0.3975p pd=2.185u as=0.101p ps=0.905u w=0.505u l=0.5u
X22 Q.t1 a_3129_107# VDD.t7 VNW.t11 pfet_05v0 ad=0.6561p pd=3.51u as=0.5346p ps=3.31u w=1.215u l=0.5u
X23 a_3129_107# a_2225_156# VDD.t9 VNW.t13 pfet_05v0 ad=0.3432p pd=2.44u as=0.3276p ps=1.62u w=0.78u l=0.5u
X24 a_2449_156# a_36_151# a_2225_156# VPW.t2 nfet_05v0 ad=0.2898p pd=2.33u as=93.59999f ps=0.88u w=0.36u l=0.6u
X25 a_1293_527# a_36_151# a_1040_527# VNW.t3 pfet_05v0 ad=0.101p pd=0.905u as=0.19315p ps=1.27u w=0.505u l=0.5u
X26 a_1697_156# a_1040_527# VSS.t3 VPW.t9 nfet_05v0 ad=86.39999f pd=0.84u as=93.59999f ps=0.88u w=0.36u l=0.6u
X27 a_3081_151# SETN.t3 a_2449_156# VPW.t0 nfet_05v0 ad=48.6f pd=0.645u as=0.3123p ps=2.38u w=0.405u l=0.6u
R0 CLK.n0 CLK.t0 13.25
R1 CLK.n0 CLK.t1 12.7755
R2 CLK CLK.n0 8.01529
R3 VSS.n5 VSS.t2 11.0252
R4 VSS.n3 VSS.t6 8.70175
R5 VSS.n2 VSS.t5 7.46717
R6 VSS.n4 VSS.n1 6.47521
R7 VSS.n3 VSS.n2 6.46859
R8 VSS.n6 VSS.n0 6.46859
R9 VSS.n1 VSS.t3 4.5505
R10 VSS.n1 VSS.t4 4.5505
R11 VSS.n2 VSS.t7 4.04494
R12 VSS.n0 VSS.t1 4.04494
R13 VSS.n0 VSS.t0 4.04494
R14 VSS.n4 VSS.n3 1.3655
R15 VSS.n5 VSS.n4 0.64625
R16 VSS.n6 VSS.n5 0.2765
R17 VSS VSS.n6 0.0125
R18 VPW.t2 VPW.t0 4436.29
R19 VPW.t3 VPW.t6 2730.59
R20 VPW.t5 VPW.t8 2190.06
R21 VPW.t10 VPW.t9 1662.1
R22 VPW.t4 VPW.t7 1662.1
R23 VPW.t6 VPW.t4 1662.1
R24 VPW.t1 VPW.t3 1662.1
R25 VPW.t8 VPW.t2 1572.35
R26 VPW.t9 VPW.t5 1503.6
R27 VPW.t7 VPW.t10 1402.4
R28 VPW VPW.t1 860.731
R29 VPW.t0 VPW.t11 64.3443
R30 SETN.t1 SETN.t2 196.589
R31 SETN.t2 SETN.t0 23.3666
R32 SETN.n0 SETN.t3 14.3867
R33 SETN.n0 SETN.t1 13.8705
R34 SETN SETN.n0 8.01589
R35 D.n0 D.t1 13.8705
R36 D.n0 D.t0 13.5055
R37 D D.n0 8.05261
R38 VDD.n6 VDD.n1 11.8275
R39 VDD.n5 VDD.t1 11.0764
R40 VDD.n7 VDD.t4 9.11778
R41 VDD.n4 VDD.t0 7.66619
R42 VDD.n1 VDD.t5 7.17999
R43 VDD.n1 VDD.t6 6.31276
R44 VDD.n3 VDD.n2 5.55267
R45 VDD.n8 VDD.n0 5.35271
R46 VDD.n2 VDD.t8 5.20563
R47 VDD.n3 VDD.t7 4.61575
R48 VDD.n2 VDD.t9 2.33383
R49 VDD.n0 VDD.t3 2.10455
R50 VDD.n0 VDD.t2 2.10455
R51 VDD.n7 VDD.n6 0.66575
R52 VDD.n5 VDD.n4 0.6035
R53 VDD.n6 VDD.n5 0.3905
R54 VDD.n4 VDD.n3 0.3545
R55 VDD.n8 VDD.n7 0.29
R56 VDD VDD.n8 0.0125
R57 VNW.t0 VNW.t5 1014.2
R58 VNW.t4 VNW.t8 749.035
R59 VNW.t6 VNW.t1 705.883
R60 VNW.t13 VNW.t11 671.816
R61 VNW.t10 VNW.t9 610.039
R62 VNW.t12 VNW.t13 517.375
R63 VNW.t7 VNW.t3 488.418
R64 VNW.t5 VNW.t6 413.793
R65 VNW.t9 VNW.t0 405.178
R66 VNW.t8 VNW.t7 393.822
R67 VNW.t2 VNW.t4 393.822
R68 VNW.t1 VNW.t12 358.05
R69 VNW.t3 VNW.t10 347.49
R70 VNW VNW.t2 241.314
R71 Q Q.t0 8.61891
R72 Q Q.t1 4.72659
C0 VNW a_2225_156# 0.20903f
C1 SETN a_2449_156# 0.30222f
C2 VNW a_836_156# 0.01368f
C3 VNW a_2449_156# 0.04382f
C4 VDD a_1353_112# 0.01626f
C5 VDD a_36_151# 1.41468f
C6 a_2225_156# a_3081_151# 0.00413f
C7 SETN VNW 0.81105f
C8 a_2449_156# a_3081_151# 0.0012f
C9 VSS a_1284_156# 0.00364f
C10 D a_1040_527# 0
C11 Q VSS 0.13127f
C12 VSS a_3129_107# 0.13677f
C13 a_1293_527# a_1040_527# 0.00215f
C14 Q a_3129_107# 0.17947f
C15 D a_448_472# 0.4001f
C16 a_1353_112# a_1040_527# 0.38742f
C17 VDD VSS 0.01381f
C18 a_36_151# a_1040_527# 0.20639f
C19 D a_836_156# 0.1081f
C20 CLK a_36_151# 0.70097f
C21 VDD Q 0.28218f
C22 VDD a_3129_107# 0.35131f
C23 a_1353_112# a_448_472# 0.31725f
C24 a_36_151# a_448_472# 0.47313f
C25 a_1353_112# a_2225_156# 0.15287f
C26 a_36_151# a_2225_156# 0.15368f
C27 a_2449_156# a_1353_112# 0
C28 VNW D 0.1615f
C29 a_36_151# a_836_156# 0.0157f
C30 a_2449_156# a_36_151# 0.00597f
C31 SETN a_1353_112# 0.07298f
C32 VNW a_1353_112# 0.21951f
C33 SETN a_36_151# 0.07777f
C34 VNW a_36_151# 0.90944f
C35 VSS a_1040_527# 0.06022f
C36 CLK VSS 0.02194f
C37 a_448_472# a_1697_156# 0.00762f
C38 a_1284_156# a_1040_527# 0
C39 VSS a_448_472# 1.07431f
C40 a_448_472# a_1284_156# 0.00269f
C41 VSS a_2225_156# 1.18908f
C42 Q a_448_472# 0
C43 a_3129_107# a_448_472# 0
C44 VSS a_836_156# 0.05001f
C45 VDD a_1040_527# 0.03968f
C46 Q a_2225_156# 0
C47 a_3129_107# a_2225_156# 0.51404f
C48 CLK VDD 0.02209f
C49 a_2449_156# a_3129_107# 0.00955f
C50 VDD a_448_472# 0.62458f
C51 SETN VSS 0.00808f
C52 VNW VSS 0.00946f
C53 VDD a_2225_156# 0.07341f
C54 SETN a_3129_107# 0.08929f
C55 VDD a_2449_156# 0.20863f
C56 VNW Q 0.03162f
C57 VNW a_3129_107# 0.32346f
C58 D a_36_151# 0.0927f
C59 a_1353_112# a_1293_527# 0
C60 a_1293_527# a_36_151# 0.00838f
C61 SETN VDD 0.12782f
C62 VNW VDD 0.5391f
C63 a_1353_112# a_36_151# 0.84088f
C64 VDD a_3081_151# 0
C65 a_448_472# a_1040_527# 0.86961f
C66 CLK a_448_472# 0.00131f
C67 a_1040_527# a_836_156# 0.06821f
C68 D VSS 0.06788f
C69 a_448_472# a_2225_156# 0.154f
C70 a_448_472# a_836_156# 0.42776f
C71 a_2449_156# a_448_472# 0.05668f
C72 a_1353_112# a_1697_156# 0.00275f
C73 SETN a_1040_527# 0.06324f
C74 a_2449_156# a_2225_156# 0.56917f
C75 VNW a_1040_527# 0.22386f
C76 VSS a_1353_112# 0.02735f
C77 VNW CLK 0.13659f
C78 VSS a_36_151# 0.28633f
C79 SETN a_448_472# 0.0839f
C80 VDD D 0.00494f
C81 VNW a_448_472# 0.40096f
C82 Q a_36_151# 0
C83 SETN a_2225_156# 0.0706f
C84 a_3129_107# a_36_151# 0
C85 Q VPW 0.10557f
C86 VSS VPW 1.35707f
C87 SETN VPW 0.71025f
C88 D VPW 0.2471f
C89 VDD VPW 0.83318f
C90 CLK VPW 0.29047f
C91 VNW VPW 6.44257f
C92 a_2449_156# VPW 0.04999f
C93 a_2225_156# VPW 0.43408f
C94 a_3129_107# VPW 0.58406f
C95 a_836_156# VPW 0.01977f
C96 a_1040_527# VPW 0.30208f
C97 a_1353_112# VPW 0.28651f
C98 a_448_472# VPW 1.21246f
C99 a_36_151# VPW 1.31409f
.ends
