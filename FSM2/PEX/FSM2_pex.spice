* NGSPICE file created from FSM2.ext - technology: gf180mcuD

.subckt dffsnq SETN Q CLK VNW VPW a_1836_282# a_855_238# a_1492_238# a_3220_277# a_1179_653#
+ a_975_282# a_175_277# a_587_598# a_383_277# a_1432_653# a_2588_282# a_2364_282#
+ a_3268_233# a_383_598# a_1423_282#
X0 a_975_282# a_855_238# a_383_598# VNW pfet_05v0 ad=0.1313p pd=1.025u as=0.22725p ps=1.91u w=0.505u l=0.5u
X1 a_383_598# a_1492_238# a_1432_653# VNW pfet_05v0 ad=0.3975p pd=2.185u as=0.101p ps=0.905u w=0.505u l=0.5u
X2 a_1836_282# a_1179_653# a_383_277# VPW nfet_05v0 ad=86.39999f pd=0.84u as=93.59999f ps=0.88u w=0.36u l=0.6u
X3 a_587_598# a_175_277# a_383_598# VNW pfet_05v0 ad=0.3806p pd=2.61u as=0.2249p ps=1.385u w=0.865u l=0.5u
X4 a_1432_653# a_175_277# a_1179_653# VNW pfet_05v0 ad=0.101p pd=0.905u as=0.19315p ps=1.27u w=0.505u l=0.5u
X5 a_2364_282# a_175_277# a_1492_238# VNW pfet_05v0 ad=0.1079p pd=0.935u as=0.27805p ps=2.17u w=0.415u l=0.5u
X6 a_2588_282# SETN a_383_598# VNW pfet_05v0 ad=0.2028p pd=1.3u as=0.3432p ps=2.44u w=0.78u l=0.5u
X7 a_1179_653# a_175_277# a_975_282# VPW nfet_05v0 ad=93.59999f pd=0.88u as=93.59999f ps=0.88u w=0.36u l=0.6u
X8 a_383_277# a_3268_233# a_3220_277# VPW nfet_05v0 ad=0.14985p pd=1.145u as=48.6f ps=0.645u w=0.405u l=0.6u
X9 a_383_277# a_1492_238# a_1423_282# VPW nfet_05v0 ad=93.59999f pd=0.88u as=62.1f ps=0.705u w=0.36u l=0.6u
X10 a_2364_282# a_587_598# a_1492_238# VPW nfet_05v0 ad=93.59999f pd=0.88u as=0.1989p ps=1.465u w=0.36u l=0.6u
X11 a_1179_653# a_587_598# a_975_282# VNW pfet_05v0 ad=0.19315p pd=1.27u as=0.1313p ps=1.025u w=0.505u l=0.5u
X12 a_587_598# a_175_277# a_383_277# VPW nfet_05v0 ad=0.1782p pd=1.69u as=0.1053p ps=0.925u w=0.405u l=0.6u
X13 a_1492_238# SETN a_1836_282# VPW nfet_05v0 ad=0.1989p pd=1.465u as=86.39999f ps=0.84u w=0.36u l=0.6u
X14 a_2588_282# a_587_598# a_2364_282# VNW pfet_05v0 ad=0.1826p pd=1.71u as=0.1079p ps=0.935u w=0.415u l=0.5u
X15 a_383_598# a_3268_233# a_2588_282# VNW pfet_05v0 ad=0.3276p pd=1.62u as=0.2028p ps=1.3u w=0.78u l=0.5u
X16 a_975_282# a_855_238# a_383_277# VPW nfet_05v0 ad=93.59999f pd=0.88u as=0.1584p ps=1.6u w=0.36u l=0.6u
X17 a_3220_277# SETN a_2588_282# VPW nfet_05v0 ad=48.6f pd=0.645u as=0.3123p ps=2.38u w=0.405u l=0.6u
X18 a_383_277# CLK a_175_277# VPW nfet_05v0 ad=0.1053p pd=0.925u as=0.1782p ps=1.69u w=0.405u l=0.6u
X19 a_3268_233# a_2364_282# a_383_277# VPW nfet_05v0 ad=0.1782p pd=1.69u as=0.14985p ps=1.145u w=0.405u l=0.6u
X20 Q a_3268_233# a_383_598# VNW pfet_05v0 ad=0.6561p pd=3.51u as=0.5346p ps=3.31u w=1.215u l=0.5u
X21 a_383_598# SETN a_1492_238# VNW pfet_05v0 ad=0.4149p pd=2.65u as=0.1521p ps=1.105u w=0.585u l=0.5u
X22 a_2588_282# a_175_277# a_2364_282# VPW nfet_05v0 ad=0.2898p pd=2.33u as=93.59999f ps=0.88u w=0.36u l=0.6u
X23 a_3268_233# a_2364_282# a_383_598# VNW pfet_05v0 ad=0.3432p pd=2.44u as=0.3276p ps=1.62u w=0.78u l=0.5u
X24 a_1492_238# a_1179_653# a_383_598# VNW pfet_05v0 ad=0.1521p pd=1.105u as=0.3975p ps=2.185u w=0.585u l=0.5u
X25 Q a_3268_233# a_383_277# VPW nfet_05v0 ad=0.3586p pd=2.51u as=0.3586p ps=2.51u w=0.815u l=0.6u
X26 a_383_598# CLK a_175_277# VNW pfet_05v0 ad=0.2249p pd=1.385u as=0.3806p ps=2.61u w=0.865u l=0.5u
X27 a_1423_282# a_587_598# a_1179_653# VPW nfet_05v0 ad=62.1f pd=0.705u as=93.59999f ps=0.88u w=0.36u l=0.6u
C0 a_383_277# a_175_277# 0.28633f
C1 a_1432_653# a_1179_653# 0.00215f
C2 SETN VNW 0.81105f
C3 a_975_282# a_175_277# 0.0157f
C4 a_3220_277# a_2364_282# 0.00413f
C5 a_383_277# a_383_598# 0.01381f
C6 a_1432_653# a_1492_238# 0
C7 SETN a_3268_233# 0.08929f
C8 a_1179_653# a_175_277# 0.20639f
C9 a_1179_653# a_383_598# 0.03968f
C10 a_175_277# a_1492_238# 0.84088f
C11 a_383_277# a_975_282# 0.05001f
C12 a_1836_282# a_1492_238# 0.00275f
C13 a_383_598# a_1492_238# 0.01626f
C14 Q a_175_277# 0
C15 a_383_277# a_1179_653# 0.06022f
C16 a_975_282# a_1179_653# 0.06821f
C17 Q a_383_598# 0.28218f
C18 a_587_598# a_855_238# 0.4001f
C19 a_383_277# a_1492_238# 0.02735f
C20 a_2588_282# a_587_598# 0.05668f
C21 VNW a_855_238# 0.1615f
C22 VNW a_2588_282# 0.04382f
C23 a_383_277# Q 0.13127f
C24 a_1423_282# a_587_598# 0.00269f
C25 VNW a_587_598# 0.40096f
C26 a_1179_653# a_1492_238# 0.38742f
C27 a_3268_233# a_2588_282# 0.00955f
C28 a_2364_282# a_175_277# 0.15368f
C29 a_3268_233# a_587_598# 0
C30 a_2364_282# a_383_598# 0.07341f
C31 a_3220_277# a_2588_282# 0.0012f
C32 a_3268_233# VNW 0.32346f
C33 SETN a_175_277# 0.07777f
C34 a_383_277# a_2364_282# 1.18908f
C35 SETN a_383_598# 0.12782f
C36 SETN a_383_277# 0.00808f
C37 a_2364_282# a_1492_238# 0.15287f
C38 CLK a_587_598# 0.00131f
C39 a_2364_282# Q 0
C40 CLK VNW 0.13659f
C41 SETN a_1179_653# 0.06324f
C42 SETN a_1492_238# 0.07298f
C43 a_175_277# a_855_238# 0.0927f
C44 a_2588_282# a_175_277# 0.00597f
C45 a_383_598# a_855_238# 0.00494f
C46 a_175_277# a_587_598# 0.47313f
C47 a_2588_282# a_383_598# 0.20863f
C48 a_1836_282# a_587_598# 0.00762f
C49 VNW a_175_277# 0.90944f
C50 a_383_598# a_587_598# 0.62458f
C51 a_383_277# a_855_238# 0.06788f
C52 a_975_282# a_855_238# 0.1081f
C53 VNW a_383_598# 0.5391f
C54 a_3268_233# a_175_277# 0
C55 a_383_277# a_587_598# 1.07431f
C56 a_383_277# a_1423_282# 0.00364f
C57 a_975_282# a_587_598# 0.42776f
C58 a_1179_653# a_855_238# 0
C59 a_3268_233# a_383_598# 0.35131f
C60 a_383_277# VNW 0.00946f
C61 SETN a_2364_282# 0.0706f
C62 a_975_282# VNW 0.01368f
C63 a_3220_277# a_383_598# 0
C64 a_1179_653# a_587_598# 0.86961f
C65 a_2588_282# a_1492_238# 0
C66 a_1179_653# a_1423_282# 0
C67 a_383_277# a_3268_233# 0.13677f
C68 a_1179_653# VNW 0.22386f
C69 a_587_598# a_1492_238# 0.31725f
C70 VNW a_1492_238# 0.21951f
C71 Q a_587_598# 0
C72 Q VNW 0.03162f
C73 CLK a_175_277# 0.70097f
C74 CLK a_383_598# 0.02209f
C75 a_3268_233# Q 0.17947f
C76 a_1432_653# a_175_277# 0.00838f
C77 a_2364_282# a_2588_282# 0.56917f
C78 a_383_277# CLK 0.02194f
C79 a_2364_282# a_587_598# 0.154f
C80 a_2364_282# VNW 0.20903f
C81 a_383_598# a_175_277# 1.41468f
C82 SETN a_2588_282# 0.30222f
C83 a_3268_233# a_2364_282# 0.51404f
C84 SETN a_587_598# 0.0839f
C85 Q VPW 0.10557f
C86 SETN VPW 0.71025f
C87 CLK VPW 0.29047f
C88 VNW VPW 6.44257f
C89 a_2588_282# VPW 0.04999f
C90 a_383_277# VPW 1.35707f
C91 a_2364_282# VPW 0.43408f
C92 a_3268_233# VPW 0.58406f
C93 a_975_282# VPW 0.01977f
C94 a_1179_653# VPW 0.30208f
C95 a_1492_238# VPW 0.28651f
C96 a_855_238# VPW 0.2471f
C97 a_587_598# VPW 1.21246f
C98 a_383_598# VPW 0.83318f
C99 a_175_277# VPW 1.31409f
.ends

.subckt or2 MODE A1 VNW VPW a_n505_n1653# a_159_n1784# a_n525_n2163# a_n317_n1653#
+ a_n113_n1653#
X0 a_159_n1784# a_n505_n1653# a_n113_n1653# VNW pfet_05v0 ad=0.5368p pd=3.32u as=0.38705p ps=2.08u w=1.22u l=0.5u
X1 a_n317_n1653# A1 a_n505_n1653# VNW pfet_05v0 ad=0.1469p pd=1.085u as=0.2486p ps=2.01u w=0.565u l=0.5u
X2 a_159_n1784# a_n505_n1653# a_n525_n2163# VPW nfet_05v0 ad=0.3608p pd=2.52u as=0.2288p ps=1.58u w=0.82u l=0.6u
X3 a_n113_n1653# MODE a_n317_n1653# VNW pfet_05v0 ad=0.38705p pd=2.08u as=0.1469p ps=1.085u w=0.565u l=0.5u
X4 a_n525_n2163# MODE a_n505_n1653# VPW nfet_05v0 ad=0.2288p pd=1.58u as=93.59999f ps=0.88u w=0.36u l=0.6u
X5 a_n505_n1653# A1 a_n525_n2163# VPW nfet_05v0 ad=93.59999f pd=0.88u as=0.1584p ps=1.6u w=0.36u l=0.6u
C0 a_n525_n2163# VNW 0.01004f
C1 a_n317_n1653# a_n113_n1653# 0.00536f
C2 VNW MODE 0.21631f
C3 a_n505_n1653# VNW 0.15724f
C4 a_n525_n2163# a_n113_n1653# 0.00865f
C5 a_n113_n1653# MODE 0.14763f
C6 a_n505_n1653# a_n113_n1653# 0.30704f
C7 a_n525_n2163# A1 0.05074f
C8 a_n525_n2163# a_159_n1784# 0.15826f
C9 VNW a_n113_n1653# 0.11771f
C10 a_n317_n1653# a_n525_n2163# 0
C11 A1 MODE 0.0624f
C12 a_159_n1784# MODE 0.0276f
C13 a_n505_n1653# A1 0.54089f
C14 a_n505_n1653# a_159_n1784# 0.18159f
C15 a_n317_n1653# MODE 0.00196f
C16 a_n317_n1653# a_n505_n1653# 0.00762f
C17 VNW A1 0.22f
C18 VNW a_159_n1784# 0.03388f
C19 a_n525_n2163# MODE 0.02575f
C20 a_n525_n2163# a_n505_n1653# 0.25049f
C21 a_n505_n1653# MODE 0.50537f
C22 a_n113_n1653# A1 0.01431f
C23 a_n113_n1653# a_159_n1784# 0.19605f
C24 MODE VPW 0.31344f
C25 A1 VPW 0.39469f
C26 VNW VPW 1.65967f
C27 a_n525_n2163# VPW 0.35972f
C28 a_159_n1784# VPW 0.10275f
C29 a_n113_n1653# VPW 0.23302f
C30 a_n505_n1653# VPW 0.34568f
.ends

.subckt nor2 REC_EN TREAT_EN A2 VSS VDD w_1180_n1958# a_1490_n1804# VSUBS
X0 a_1490_n1804# REC_EN VDD w_1180_n1958# pfet_05v0 ad=0.4087p pd=1.89u as=0.5368p ps=3.32u w=1.22u l=0.5u
X1 TREAT_EN REC_EN VSS VSUBS nfet_05v0 ad=0.1469p pd=1.085u as=0.2486p ps=2.01u w=0.565u l=0.6u
X2 TREAT_EN A2 a_1490_n1804# w_1180_n1958# pfet_05v0 ad=0.5368p pd=3.32u as=0.4087p ps=1.89u w=1.22u l=0.5u
X3 VSS A2 TREAT_EN VSUBS nfet_05v0 ad=0.2486p pd=2.01u as=0.1469p ps=1.085u w=0.565u l=0.6u
C0 TREAT_EN w_1180_n1958# 0.01978f
C1 A2 w_1180_n1958# 0.13314f
C2 w_1180_n1958# REC_EN 0.1288f
C3 TREAT_EN A2 0.57853f
C4 VDD w_1180_n1958# 0.09421f
C5 TREAT_EN REC_EN 0.37841f
C6 A2 REC_EN 0.03781f
C7 TREAT_EN VDD 0.11792f
C8 A2 VDD 0.0227f
C9 VSS a_1490_n1804# 0
C10 VDD REC_EN 0.25532f
C11 VSS w_1180_n1958# 0.01214f
C12 TREAT_EN a_1490_n1804# 0.02369f
C13 TREAT_EN VSS 0.08738f
C14 A2 VSS 0.16225f
C15 a_1490_n1804# REC_EN 0.00898f
C16 VDD a_1490_n1804# 0.01396f
C17 VSS REC_EN 0.04452f
C18 VSS VDD 0.02591f
C19 VDD VSUBS 0.21903f
C20 TREAT_EN VSUBS 0.05889f
C21 VSS VSUBS 0.3776f
C22 A2 VSUBS 0.32864f
C23 REC_EN VSUBS 0.33451f
C24 w_1180_n1958# VSUBS 1.31158f
.ends

.subckt dffrnq RN Q CLK VNW VPW a_1002_n2102# a_1458_n1702# a_2250_n1702# a_2667_n1842#
+ a_38_n1706# a_798_n2102# a_698_n2146# a_450_n2119# a_1310_n2146# a_246_n2119# a_246_n1706#
+ a_1206_n2102# a_1290_n1702# a_2562_n1702# a_3043_n1702#
X0 a_246_n1706# RN a_1458_n1702# VPW nfet_05v0 ad=0.2016p pd=1.48u as=43.2f ps=0.6u w=0.36u l=0.6u
X1 a_3043_n1702# RN a_246_n1706# VPW nfet_05v0 ad=0.134p pd=1.1u as=0.1224p ps=1.04u w=0.36u l=0.6u
X2 a_2562_n1702# a_450_n2119# a_2250_n1702# VNW pfet_05v0 ad=0.1313p pd=1.025u as=0.25375p ps=1.51u w=0.505u l=0.5u
X3 a_798_n2102# a_698_n2146# a_246_n2119# VNW pfet_05v0 ad=0.2028p pd=1.3u as=0.3432p ps=2.44u w=0.78u l=0.5u
X4 a_246_n1706# a_2667_n1842# a_2562_n1702# VPW nfet_05v0 ad=0.1224p pd=1.04u as=94.5f ps=0.885u w=0.36u l=0.6u
X5 a_450_n2119# a_38_n1706# a_246_n1706# VPW nfet_05v0 ad=0.1782p pd=1.69u as=0.1053p ps=0.925u w=0.405u l=0.6u
X6 a_1206_n2102# a_38_n1706# a_1002_n2102# VNW pfet_05v0 ad=0.2028p pd=1.3u as=0.2028p ps=1.3u w=0.78u l=0.5u
X7 a_2667_n1842# a_2250_n1702# a_3043_n1702# VPW nfet_05v0 ad=0.176p pd=1.68u as=0.134p ps=1.1u w=0.4u l=0.6u
X8 a_1206_n2102# RN a_246_n2119# VNW pfet_05v0 ad=0.3432p pd=2.44u as=0.45p ps=2.02u w=0.78u l=0.5u
X9 a_2562_n1702# a_38_n1706# a_2250_n1702# VPW nfet_05v0 ad=94.5f pd=0.885u as=0.2007p ps=1.475u w=0.36u l=0.6u
X10 a_246_n1706# CLK a_38_n1706# VPW nfet_05v0 ad=0.1053p pd=0.925u as=0.1782p ps=1.69u w=0.405u l=0.6u
X11 a_1310_n2146# a_1002_n2102# a_246_n2119# VNW pfet_05v0 ad=0.2424p pd=1.465u as=0.2222p ps=1.89u w=0.505u l=0.5u
X12 a_2667_n1842# RN a_246_n2119# VNW pfet_05v0 ad=0.26p pd=1.52u as=0.29465p ps=1.74u w=1u l=0.5u
X13 a_2250_n1702# a_450_n2119# a_1310_n2146# VPW nfet_05v0 ad=0.2007p pd=1.475u as=0.2007p ps=1.475u w=0.36u l=0.6u
X14 a_246_n2119# CLK a_38_n1706# VNW pfet_05v0 ad=0.2249p pd=1.385u as=0.3806p ps=2.61u w=0.865u l=0.5u
X15 a_246_n2119# a_2667_n1842# a_2562_n1702# VNW pfet_05v0 ad=0.29465p pd=1.74u as=0.1313p ps=1.025u w=0.505u l=0.5u
X16 a_1290_n1702# a_450_n2119# a_1002_n2102# VPW nfet_05v0 ad=43.2f pd=0.6u as=93.59999f ps=0.88u w=0.36u l=0.6u
X17 Q a_2667_n1842# a_246_n2119# VNW pfet_05v0 ad=0.63787p pd=3.48u as=0.5346p ps=3.31u w=1.215u l=0.5u
X18 a_246_n2119# a_1310_n2146# a_1206_n2102# VNW pfet_05v0 ad=0.45p pd=2.02u as=0.2028p ps=1.3u w=0.78u l=0.5u
X19 Q a_2667_n1842# a_246_n1706# VPW nfet_05v0 ad=0.42787p pd=2.68u as=0.3586p ps=2.51u w=0.815u l=0.6u
X20 a_798_n2102# a_698_n2146# a_246_n1706# VPW nfet_05v0 ad=93.59999f pd=0.88u as=0.1584p ps=1.6u w=0.36u l=0.6u
X21 a_2250_n1702# a_38_n1706# a_1310_n2146# VNW pfet_05v0 ad=0.25375p pd=1.51u as=0.2424p ps=1.465u w=0.505u l=0.5u
X22 a_246_n2119# a_2250_n1702# a_2667_n1842# VNW pfet_05v0 ad=0.44p pd=2.88u as=0.26p ps=1.52u w=1u l=0.5u
X23 a_1002_n2102# a_38_n1706# a_798_n2102# VPW nfet_05v0 ad=93.59999f pd=0.88u as=93.59999f ps=0.88u w=0.36u l=0.6u
X24 a_450_n2119# a_38_n1706# a_246_n2119# VNW pfet_05v0 ad=0.3806p pd=2.61u as=0.2249p ps=1.385u w=0.865u l=0.5u
X25 a_1002_n2102# a_450_n2119# a_798_n2102# VNW pfet_05v0 ad=0.2028p pd=1.3u as=0.2028p ps=1.3u w=0.78u l=0.5u
X26 a_1458_n1702# a_1310_n2146# a_1290_n1702# VPW nfet_05v0 ad=43.2f pd=0.6u as=43.2f ps=0.6u w=0.36u l=0.6u
X27 a_1310_n2146# a_1002_n2102# a_246_n1706# VPW nfet_05v0 ad=0.2007p pd=1.475u as=0.2016p ps=1.48u w=0.36u l=0.6u
C0 a_38_n1706# a_2667_n1842# 0.01904f
C1 RN a_246_n2119# 0.03498f
C2 a_246_n1706# Q 0.11398f
C3 a_1002_n2102# a_798_n2102# 0.04844f
C4 a_2562_n1702# a_2667_n1842# 0.11606f
C5 a_1310_n2146# a_246_n2119# 0.09419f
C6 a_38_n1706# a_450_n2119# 0.53697f
C7 a_2562_n1702# a_450_n2119# 0.27749f
C8 VNW CLK 0.13704f
C9 a_1002_n2102# a_246_n2119# 0.11921f
C10 a_1002_n2102# a_1290_n1702# 0
C11 a_2667_n1842# a_3043_n1702# 0.00177f
C12 a_38_n1706# a_2562_n1702# 0.00367f
C13 a_1002_n2102# a_698_n2146# 0
C14 VNW Q 0.03166f
C15 a_246_n1706# a_2667_n1842# 0.18639f
C16 RN Q 0
C17 a_450_n2119# a_246_n1706# 1.20327f
C18 a_450_n2119# a_1206_n2102# 0.009f
C19 a_38_n1706# a_246_n1706# 0.29961f
C20 a_2562_n1702# a_246_n1706# 0.1285f
C21 VNW a_2667_n1842# 0.35472f
C22 a_450_n2119# VNW 0.34128f
C23 a_38_n1706# a_1206_n2102# 0.007f
C24 RN a_2667_n1842# 0.33647f
C25 a_246_n2119# a_2250_n1702# 1.11667f
C26 a_450_n2119# RN 0.07873f
C27 a_246_n2119# a_798_n2102# 0
C28 a_450_n2119# a_1310_n2146# 0.8821f
C29 a_38_n1706# VNW 1.28833f
C30 a_2562_n1702# VNW 0.02016f
C31 a_698_n2146# a_798_n2102# 0.08286f
C32 a_1002_n2102# a_450_n2119# 0.36196f
C33 a_38_n1706# RN 0.0801f
C34 a_38_n1706# a_1310_n2146# 0.05539f
C35 a_2562_n1702# RN 0.03878f
C36 a_698_n2146# a_246_n2119# 0.00937f
C37 a_1002_n2102# a_38_n1706# 0.08126f
C38 Q a_2250_n1702# 0.01436f
C39 VNW a_246_n1706# 0.0106f
C40 RN a_3043_n1702# 0.01068f
C41 CLK a_246_n2119# 0.02303f
C42 VNW a_1206_n2102# 0.01627f
C43 RN a_246_n1706# 0.45994f
C44 Q a_246_n2119# 0.1499f
C45 a_246_n1706# a_1310_n2146# 0.01482f
C46 RN a_1206_n2102# 0.02104f
C47 a_1002_n2102# a_246_n1706# 0.04356f
C48 a_1206_n2102# a_1310_n2146# 0.02667f
C49 a_2667_n1842# a_2250_n1702# 0.63332f
C50 a_450_n2119# a_2250_n1702# 0.51037f
C51 a_450_n2119# a_1458_n1702# 0.00227f
C52 RN VNW 0.32949f
C53 a_1002_n2102# a_1206_n2102# 0.66083f
C54 VNW a_1310_n2146# 0.14901f
C55 a_450_n2119# a_798_n2102# 0.40164f
C56 a_246_n2119# a_2667_n1842# 0.10205f
C57 a_38_n1706# a_2250_n1702# 0.0428f
C58 a_1002_n2102# VNW 0.24136f
C59 RN a_1310_n2146# 0.07929f
C60 a_450_n2119# a_246_n2119# 0.45627f
C61 a_1290_n1702# a_450_n2119# 0.00207f
C62 a_2562_n1702# a_2250_n1702# 0.11969f
C63 a_38_n1706# a_798_n2102# 0.01185f
C64 a_698_n2146# a_450_n2119# 0.32879f
C65 a_1002_n2102# RN 0.0832f
C66 a_1002_n2102# a_1310_n2146# 0.93419f
C67 a_38_n1706# a_246_n2119# 0.41709f
C68 a_2562_n1702# a_246_n2119# 0.00217f
C69 a_450_n2119# CLK 0.00276f
C70 a_698_n2146# a_38_n1706# 0.09411f
C71 a_246_n1706# a_2250_n1702# 0.03193f
C72 Q a_2667_n1842# 0.10944f
C73 a_246_n1706# a_1458_n1702# 0.0019f
C74 a_246_n1706# a_798_n2102# 0.05215f
C75 a_38_n1706# CLK 0.6696f
C76 a_1290_n1702# a_246_n1706# 0.0017f
C77 a_246_n1706# a_246_n2119# 0.01338f
C78 a_38_n1706# Q 0
C79 VNW a_2250_n1702# 0.21243f
C80 a_698_n2146# a_246_n1706# 0.06462f
C81 a_1206_n2102# a_246_n2119# 0.28263f
C82 VNW a_798_n2102# 0.01023f
C83 RN a_2250_n1702# 0.09434f
C84 a_450_n2119# a_2667_n1842# 0.02046f
C85 a_1310_n2146# a_2250_n1702# 0.05672f
C86 a_246_n1706# CLK 0.02288f
C87 VNW a_246_n2119# 0.50314f
C88 a_1002_n2102# a_2250_n1702# 0.00123f
C89 a_698_n2146# VNW 0.12823f
C90 a_1002_n2102# a_1458_n1702# 0
C91 Q VPW 0.11299f
C92 RN VPW 1.36673f
C93 CLK VPW 0.29124f
C94 VNW VPW 6.1377f
C95 a_1206_n2102# VPW 0.01297f
C96 a_246_n2119# VPW 0.79945f
C97 a_2562_n1702# VPW 0.01697f
C98 a_2250_n1702# VPW 0.37166f
C99 a_2667_n1842# VPW 0.62251f
C100 a_1002_n2102# VPW 0.29173f
C101 a_798_n2102# VPW 0.02321f
C102 a_1310_n2146# VPW 0.27904f
C103 a_698_n2146# VPW 0.25341f
C104 a_450_n2119# VPW 0.68441f
C105 a_246_n1706# VPW 1.42701f
C106 a_38_n1706# VPW 1.43589f
.ends

.subckt and2 A1 VNW VPW a_3638_891# a_3366_452# a_3758_935# a_3366_935# a_3574_935#
+ a_4026_452#
X0 a_4026_452# a_3366_935# a_3366_452# VNW pfet_05v0 ad=0.5346p pd=3.31u as=0.40575p ps=2.055u w=1.215u l=0.5u
X1 a_3758_935# a_3638_891# a_3574_935# VPW nfet_05v0 ad=0.23405p pd=1.555u as=58.39999f ps=0.685u w=0.365u l=0.6u
X2 a_3366_935# A1 a_3366_452# VNW pfet_05v0 ad=0.156p pd=1.12u as=0.264p ps=2.08u w=0.6u l=0.5u
X3 a_3574_935# A1 a_3366_935# VPW nfet_05v0 ad=58.39999f pd=0.685u as=0.1606p ps=1.61u w=0.365u l=0.6u
X4 a_3366_452# a_3638_891# a_3366_935# VNW pfet_05v0 ad=0.40575p pd=2.055u as=0.156p ps=1.12u w=0.6u l=0.5u
X5 a_4026_452# a_3366_935# a_3758_935# VPW nfet_05v0 ad=0.3586p pd=2.51u as=0.23405p ps=1.555u w=0.815u l=0.6u
C0 a_3366_452# a_3366_935# 0.13019f
C1 a_3758_935# a_4026_452# 0.10282f
C2 a_3366_452# a_3638_891# 0.18402f
C3 a_3574_935# a_4026_452# 0
C4 a_3366_452# a_4026_452# 0.15821f
C5 VNW a_3758_935# 0.00793f
C6 a_3366_935# A1 0.37712f
C7 a_3638_891# A1 0.06143f
C8 VNW a_3366_452# 0.12561f
C9 a_4026_452# A1 0
C10 a_3638_891# a_3366_935# 0.47278f
C11 a_4026_452# a_3366_935# 0.21527f
C12 a_3574_935# a_3758_935# 0.00145f
C13 a_4026_452# a_3638_891# 0.02017f
C14 a_3366_452# a_3758_935# 0.01413f
C15 VNW A1 0.20677f
C16 VNW a_3366_935# 0.1625f
C17 VNW a_3638_891# 0.20463f
C18 VNW a_4026_452# 0.03284f
C19 a_3758_935# A1 0.01116f
C20 a_3758_935# a_3366_935# 0.24575f
C21 a_3574_935# a_3366_935# 0.00334f
C22 a_3758_935# a_3638_891# 0.01199f
C23 a_3366_452# A1 0.04397f
C24 A1 VPW 0.32127f
C25 VNW VPW 1.65967f
C26 a_3366_452# VPW 0.25125f
C27 a_4026_452# VPW 0.09648f
C28 a_3638_891# VPW 0.26226f
C29 a_3758_935# VPW 0.40776f
C30 a_3366_935# VPW 0.37412f
.ends

.subckt FSM2 MODE RSTn VSS CLK VDD TREAT_EN REC_EN
Xdffsnq_0 RSTn S0 CLK VDD VSS dffsnq_0/a_1836_282#
+ m2_3305_n910# dffsnq_0/a_1492_238# dffsnq_0/a_3220_277# dffsnq_0/a_1179_653# dffsnq_0/a_975_282#
+ dffsnq_0/a_175_277# dffsnq_0/a_587_598# VSS dffsnq_0/a_1432_653# dffsnq_0/a_2588_282#
+ dffsnq_0/a_2364_282# dffsnq_0/a_3268_233# VDD dffsnq_0/a_1423_282# dffsnq
Xor2_0 MODE REC_EN VDD VSS or2_0/a_n505_n1653# m2_3305_n910# VSS
+ or2_0/a_n317_n1653# VDD or2
Xnor2_0 REC_EN TREAT_EN S0 VSS VDD VDD nor2_0/a_1490_n1804#
+ VSS nor2
Xdffrnq_0 RSTn REC_EN CLK VDD VSS dffrnq_0/a_1002_n2102#
+ dffrnq_0/a_1458_n1702# dffrnq_0/a_2250_n1702# dffrnq_0/a_2667_n1842# dffrnq_0/a_38_n1706#
+ dffrnq_0/a_798_n2102# m2_3239_n1773# dffrnq_0/a_450_n2119# dffrnq_0/a_1310_n2146#
+ VDD VSS dffrnq_0/a_1206_n2102# dffrnq_0/a_1290_n1702# dffrnq_0/a_2562_n1702#
+ dffrnq_0/a_3043_n1702# dffrnq
Xand2_0 S0 VDD VSS MODE VDD VSS and2_0/a_3366_935#
+ and2_0/a_3574_935# m2_3239_n1773# and2
C0 dffsnq_0/a_2364_282# VDD 0.00239f
C1 REC_EN TREAT_EN 0.03989f
C2 S0 dffrnq_0/a_798_n2102# 0.02803f
C3 S0 RSTn 0.03746f
C4 dffsnq_0/a_3220_277# REC_EN 0
C5 MODE m2_3305_n910# 0.00194f
C6 or2_0/a_n505_n1653# REC_EN 0.03149f
C7 S0 dffrnq_0/a_2562_n1702# 0.0365f
C8 dffrnq_0/a_38_n1706# m2_3239_n1773# 0.13668f
C9 S0 and2_0/a_3574_935# 0
C10 S0 dffrnq_0/a_1290_n1702# 0
C11 dffsnq_0/a_587_598# m2_3305_n910# 0.03797f
C12 dffrnq_0/a_2250_n1702# REC_EN 0.02201f
C13 S0 VDD 0.48506f
C14 S0 dffsnq_0/a_3268_233# 0.0078f
C15 dffsnq_0/a_2364_282# REC_EN 0.01621f
C16 MODE m2_3239_n1773# 0.00154f
C17 or2_0/a_n505_n1653# m2_3305_n910# 0.00284f
C18 dffrnq_0/a_1002_n2102# VDD 0
C19 dffsnq_0/a_1492_238# RSTn 0
C20 m2_3239_n1773# TREAT_EN 0
C21 dffrnq_0/a_38_n1706# CLK 0.01222f
C22 or2_0/a_n505_n1653# m2_3239_n1773# 0.00108f
C23 dffsnq_0/a_175_277# CLK 0.01222f
C24 dffsnq_0/a_2364_282# dffrnq_0/a_2667_n1842# 0
C25 S0 REC_EN 0.80131f
C26 dffrnq_0/a_798_n2102# dffrnq_0/a_450_n2119# -0.01121f
C27 REC_EN dffrnq_0/a_1002_n2102# 0.01893f
C28 MODE CLK 0.00675f
C29 dffsnq_0/a_1492_238# VDD 0
C30 dffsnq_0/a_2588_282# RSTn 0
C31 and2_0/a_3366_935# VDD -0.00943f
C32 S0 dffrnq_0/a_2667_n1842# 0.11643f
C33 CLK TREAT_EN 0
C34 dffrnq_0/a_38_n1706# dffsnq_0/a_1179_653# 0
C35 dffrnq_0/a_450_n2119# VDD -0
C36 or2_0/a_n505_n1653# CLK 0.01188f
C37 dffrnq_0/a_1310_n2146# VDD 0
C38 dffrnq_0/a_38_n1706# dffsnq_0/a_175_277# 0.03768f
C39 dffsnq_0/a_1492_238# REC_EN 0.01008f
C40 S0 m2_3239_n1773# 0.45662f
C41 dffsnq_0/a_2588_282# VDD -0
C42 MODE dffsnq_0/a_1179_653# 0
C43 dffsnq_0/a_1836_282# REC_EN 0
C44 m2_3239_n1773# dffrnq_0/a_1002_n2102# 0
C45 MODE dffrnq_0/a_38_n1706# 0
C46 REC_EN and2_0/a_3366_935# 0.06825f
C47 MODE dffsnq_0/a_175_277# 0
C48 dffsnq_0/a_587_598# dffrnq_0/a_38_n1706# 0
C49 dffrnq_0/a_450_n2119# REC_EN 0.16798f
C50 dffsnq_0/a_587_598# dffsnq_0/a_175_277# -0
C51 dffsnq_0/a_1492_238# m2_3305_n910# 0
C52 REC_EN dffrnq_0/a_1310_n2146# 0.03455f
C53 dffsnq_0/a_2588_282# REC_EN 0.00622f
C54 dffsnq_0/a_587_598# MODE 0
C55 nor2_0/a_1490_n1804# VDD 0
C56 dffsnq_0/a_975_282# VDD -0
C57 or2_0/a_n505_n1653# dffsnq_0/a_175_277# 0.00156f
C58 S0 CLK 0.0401f
C59 RSTn VDD 0.00464f
C60 dffrnq_0/a_798_n2102# VDD -0
C61 dffsnq_0/a_3268_233# RSTn 0
C62 dffrnq_0/a_2562_n1702# VDD -0
C63 or2_0/a_n505_n1653# MODE 0.00232f
C64 dffsnq_0/a_175_277# dffrnq_0/a_1206_n2102# 0
C65 m2_3239_n1773# and2_0/a_3366_935# 0.00515f
C66 m2_3239_n1773# dffrnq_0/a_450_n2119# 0.07464f
C67 nor2_0/a_1490_n1804# REC_EN 0.00313f
C68 REC_EN dffsnq_0/a_975_282# 0.00273f
C69 m2_3239_n1773# dffrnq_0/a_1310_n2146# 0
C70 dffsnq_0/a_3268_233# VDD 0.00814f
C71 dffrnq_0/a_798_n2102# REC_EN 0.01189f
C72 REC_EN RSTn 0.08278f
C73 dffsnq_0/a_1423_282# REC_EN 0
C74 S0 dffrnq_0/a_38_n1706# 0.0792f
C75 dffrnq_0/a_2562_n1702# REC_EN 0.02552f
C76 and2_0/a_3574_935# REC_EN 0.00105f
C77 dffrnq_0/a_1290_n1702# REC_EN 0
C78 S0 dffsnq_0/a_175_277# 0
C79 dffsnq_0/a_975_282# m2_3305_n910# 0.00259f
C80 CLK and2_0/a_3366_935# 0.01029f
C81 dffsnq_0/a_175_277# dffrnq_0/a_1002_n2102# 0
C82 S0 dffrnq_0/a_3043_n1702# 0
C83 S0 MODE 0.04189f
C84 RSTn m2_3305_n910# 0
C85 dffsnq_0/a_2364_282# dffrnq_0/a_2250_n1702# 0
C86 REC_EN VDD 0.22949f
C87 dffsnq_0/a_3268_233# REC_EN 0.00916f
C88 S0 dffrnq_0/a_1458_n1702# 0
C89 S0 dffsnq_0/a_587_598# 0
C90 MODE dffrnq_0/a_1002_n2102# 0
C91 dffsnq_0/a_587_598# dffrnq_0/a_1002_n2102# 0
C92 S0 TREAT_EN 0.02181f
C93 S0 dffsnq_0/a_3220_277# 0
C94 dffrnq_0/a_798_n2102# m2_3239_n1773# 0.02259f
C95 m2_3239_n1773# RSTn 0
C96 m2_3305_n910# VDD 0.06095f
C97 S0 or2_0/a_n505_n1653# 0
C98 dffrnq_0/a_38_n1706# dffsnq_0/a_1492_238# 0
C99 dffrnq_0/a_2667_n1842# VDD 0.00862f
C100 dffsnq_0/a_3268_233# dffrnq_0/a_2667_n1842# 0.0011f
C101 S0 dffrnq_0/a_2250_n1702# 0.10297f
C102 dffrnq_0/a_450_n2119# dffsnq_0/a_1179_653# 0
C103 or2_0/a_n317_n1653# VDD 0
C104 dffrnq_0/a_38_n1706# and2_0/a_3366_935# 0.00138f
C105 S0 dffrnq_0/a_1206_n2102# 0.03411f
C106 S0 dffsnq_0/a_2364_282# 0.00366f
C107 m2_3239_n1773# VDD 0.00785f
C108 dffrnq_0/a_1310_n2146# dffsnq_0/a_1179_653# 0
C109 dffsnq_0/a_1432_653# REC_EN 0
C110 dffsnq_0/a_175_277# dffrnq_0/a_450_n2119# 0
C111 REC_EN m2_3305_n910# 0.0677f
C112 dffsnq_0/a_175_277# dffrnq_0/a_1310_n2146# 0
C113 MODE and2_0/a_3366_935# 0.00751f
C114 dffrnq_0/a_2667_n1842# REC_EN 0.04664f
C115 MODE dffrnq_0/a_450_n2119# 0
C116 CLK RSTn 0.00159f
C117 dffsnq_0/a_587_598# dffrnq_0/a_450_n2119# 0.00481f
C118 or2_0/a_n317_n1653# REC_EN 0
C119 dffsnq_0/a_587_598# dffrnq_0/a_1310_n2146# 0
C120 TREAT_EN and2_0/a_3366_935# 0.0089f
C121 m2_3239_n1773# REC_EN 0.3421f
C122 or2_0/a_n505_n1653# and2_0/a_3366_935# 0.0036f
C123 S0 dffrnq_0/a_1002_n2102# 0.12522f
C124 dffsnq_0/a_1492_238# dffrnq_0/a_1206_n2102# 0
C125 CLK VDD 0.00924f
C126 m2_3239_n1773# m2_3305_n910# 0
C127 RSTn dffsnq_0/a_1179_653# 0.00638f
C128 dffsnq_0/a_175_277# RSTn 0.00151f
C129 MODE dffsnq_0/a_975_282# 0
C130 CLK REC_EN 0.01441f
C131 S0 dffsnq_0/a_1492_238# 0
C132 dffsnq_0/a_587_598# dffsnq_0/a_975_282# -0
C133 dffsnq_0/a_1179_653# VDD -0
C134 dffrnq_0/a_798_n2102# MODE 0
C135 dffsnq_0/a_1492_238# dffrnq_0/a_1002_n2102# 0
C136 dffrnq_0/a_38_n1706# VDD 0.00185f
C137 dffsnq_0/a_587_598# RSTn 0.04556f
C138 S0 and2_0/a_3366_935# 0.10792f
C139 dffsnq_0/a_175_277# VDD 0
C140 S0 dffrnq_0/a_450_n2119# 0.13606f
C141 CLK m2_3305_n910# 0.08319f
C142 S0 dffrnq_0/a_1310_n2146# 0.08139f
C143 MODE VDD 0.00701f
C144 S0 dffsnq_0/a_2588_282# 0
C145 dffsnq_0/a_587_598# VDD -0
C146 REC_EN dffsnq_0/a_1179_653# 0.00787f
C147 dffrnq_0/a_38_n1706# REC_EN 0.04348f
C148 CLK m2_3239_n1773# 0.04562f
C149 dffsnq_0/a_175_277# REC_EN 0.01819f
C150 TREAT_EN VDD 0.01034f
C151 dffsnq_0/a_2364_282# RSTn 0
C152 or2_0/a_n505_n1653# VDD 0.02363f
C153 REC_EN dffrnq_0/a_3043_n1702# 0
C154 dffsnq_0/a_1179_653# m2_3305_n910# 0.00217f
C155 dffrnq_0/a_450_n2119# dffsnq_0/a_1492_238# 0
C156 dffrnq_0/a_2250_n1702# VDD 0.00121f
C157 dffsnq_0/a_3268_233# dffrnq_0/a_2250_n1702# 0.00269f
C158 MODE REC_EN 0.02483f
C159 dffrnq_0/a_1458_n1702# REC_EN 0
C160 dffrnq_0/a_38_n1706# m2_3305_n910# 0
C161 dffsnq_0/a_587_598# REC_EN 0.02152f
C162 S0 nor2_0/a_1490_n1804# 0
C163 dffsnq_0/a_175_277# m2_3305_n910# 0.18381f
C164 dffsnq_0/a_1492_238# dffrnq_0/a_1310_n2146# 0.00298f
C165 dffrnq_0/a_1206_n2102# VDD 0
C166 S0 VSS 1.59025f
C167 m2_3239_n1773# VSS 0.34956f
C168 m2_3305_n910# VSS 0.42172f
C169 REC_EN VSS 2.59992f
C170 and2_0/a_3366_935# VSS 0.39003f
C171 RSTn VSS 2.29321f
C172 CLK VSS 0.85504f
C173 dffrnq_0/a_1206_n2102# VSS 0.01297f
C174 dffrnq_0/a_2562_n1702# VSS 0.01697f
C175 dffrnq_0/a_2250_n1702# VSS 0.37403f
C176 dffrnq_0/a_2667_n1842# VSS 0.62674f
C177 dffrnq_0/a_1002_n2102# VSS 0.29173f
C178 dffrnq_0/a_798_n2102# VSS 0.02321f
C179 dffrnq_0/a_1310_n2146# VSS 0.28051f
C180 dffrnq_0/a_450_n2119# VSS 0.68629f
C181 dffrnq_0/a_38_n1706# VSS 1.44454f
C182 TREAT_EN VSS 0.05875f
C183 MODE VSS 0.88592f
C184 or2_0/a_n505_n1653# VSS 0.35258f
C185 VDD VSS 21.66842f
C186 dffsnq_0/a_2588_282# VSS 0.04999f
C187 dffsnq_0/a_2364_282# VSS 0.43821f
C188 dffsnq_0/a_3268_233# VSS 0.59174f
C189 dffsnq_0/a_975_282# VSS 0.01977f
C190 dffsnq_0/a_1179_653# VSS 0.3045f
C191 dffsnq_0/a_1492_238# VSS 0.28879f
C192 dffsnq_0/a_587_598# VSS 1.23015f
C193 dffsnq_0/a_175_277# VSS 1.33067f
.ends
