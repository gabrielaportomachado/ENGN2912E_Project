* Extracted by KLayout with GF180MCU LVS runset on : 01/09/2026 01:40

.SUBCKT FSM2 VDD TREAT_EN A1|Q|REC_EN A1|A2|Q MODE CLK RN|SETN VSS
M$1 \$4 A1|A2|Q VDD VDD pfet_05v0 L=0.5U W=0.6U AS=0.264P AD=0.156P PS=2.08U
+ PD=1.12U
M$2 VDD MODE \$4 VDD pfet_05v0 L=0.5U W=0.6U AS=0.156P AD=0.40575P PS=1.12U
+ PD=2.055U
M$3 \$5 \$4 VDD VDD pfet_05v0 L=0.5U W=1.215U AS=0.40575P AD=0.5346P PS=2.055U
+ PD=3.31U
M$4 \$16 \$15 VDD VDD pfet_05v0 L=0.5U W=0.505U AS=0.2222P AD=0.2424P PS=1.89U
+ PD=1.465U
M$5 \$9 \$6 \$16 VDD pfet_05v0 L=0.5U W=0.505U AS=0.2424P AD=0.2537625P
+ PS=1.465U PD=1.51U
M$6 \$17 \$7 \$9 VDD pfet_05v0 L=0.5U W=0.505U AS=0.2537625P AD=0.1313P
+ PS=1.51U PD=1.025U
M$7 \$17 \$18 VDD VDD pfet_05v0 L=0.5U W=0.505U AS=0.29465P AD=0.1313P PS=1.74U
+ PD=1.025U
M$8 \$18 RN|SETN VDD VDD pfet_05v0 L=0.5U W=1U AS=0.29465P AD=0.26P PS=1.74U
+ PD=1.52U
M$9 VDD \$9 \$18 VDD pfet_05v0 L=0.5U W=1U AS=0.26P AD=0.44P PS=1.52U PD=2.88U
M$10 \$22 A1|Q|REC_EN VDD VDD pfet_05v0 L=0.5U W=1.22U AS=0.5368P AD=0.4087P
+ PS=3.32U PD=1.89U
M$11 TREAT_EN A1|A2|Q \$22 VDD pfet_05v0 L=0.5U W=1.22U AS=0.4087P AD=0.5368P
+ PS=1.89U PD=3.32U
M$12 VDD CLK \$6 VDD pfet_05v0 L=0.5U W=0.865U AS=0.3806P AD=0.2249P PS=2.61U
+ PD=1.385U
M$13 \$7 \$6 VDD VDD pfet_05v0 L=0.5U W=0.865U AS=0.2249P AD=0.3806P PS=1.385U
+ PD=2.61U
M$14 \$14 \$5 VDD VDD pfet_05v0 L=0.5U W=0.78U AS=0.3432P AD=0.2028P PS=2.44U
+ PD=1.3U
M$15 \$15 \$7 \$14 VDD pfet_05v0 L=0.5U W=0.78U AS=0.2028P AD=0.2028P PS=1.3U
+ PD=1.3U
M$16 \$8 \$6 \$15 VDD pfet_05v0 L=0.5U W=0.78U AS=0.2028P AD=0.2028P PS=1.3U
+ PD=1.3U
M$17 \$8 \$16 VDD VDD pfet_05v0 L=0.5U W=0.78U AS=0.45P AD=0.2028P PS=2.02U
+ PD=1.3U
M$18 \$8 RN|SETN VDD VDD pfet_05v0 L=0.5U W=0.78U AS=0.45P AD=0.3432P PS=2.02U
+ PD=2.44U
M$19 A1|Q|REC_EN \$18 VDD VDD pfet_05v0 L=0.5U W=1.215U AS=0.5346P AD=0.637875P
+ PS=3.31U PD=3.48U
M$20 \$42 \$45 \$49 VDD pfet_05v0 L=0.5U W=0.415U AS=0.27805P AD=0.1079P
+ PS=2.17U PD=0.935U
M$21 \$50 \$47 \$42 VDD pfet_05v0 L=0.5U W=0.415U AS=0.1079P AD=0.1826P
+ PS=0.935U PD=1.71U
M$22 \$46 \$44 VDD VDD pfet_05v0 L=0.5U W=0.505U AS=0.22725P AD=0.1313P
+ PS=1.91U PD=1.025U
M$23 \$48 \$47 \$46 VDD pfet_05v0 L=0.5U W=0.505U AS=0.1313P AD=0.1931625P
+ PS=1.025U PD=1.27U
M$24 \$66 \$45 \$48 VDD pfet_05v0 L=0.5U W=0.505U AS=0.1931625P AD=0.101P
+ PS=1.27U PD=0.905U
M$25 VDD \$49 \$66 VDD pfet_05v0 L=0.5U W=0.505U AS=0.101P AD=0.3975P PS=0.905U
+ PD=2.185U
M$26 \$49 \$48 VDD VDD pfet_05v0 L=0.5U W=0.585U AS=0.3975P AD=0.1521P
+ PS=2.185U PD=1.105U
M$27 VDD RN|SETN \$49 VDD pfet_05v0 L=0.5U W=0.585U AS=0.1521P AD=0.4149P
+ PS=1.105U PD=2.65U
M$28 VDD CLK \$45 VDD pfet_05v0 L=0.5U W=0.865U AS=0.3806P AD=0.2249P PS=2.61U
+ PD=1.385U
M$29 \$47 \$45 VDD VDD pfet_05v0 L=0.5U W=0.865U AS=0.2249P AD=0.3806P
+ PS=1.385U PD=2.61U
M$30 \$50 RN|SETN VDD VDD pfet_05v0 L=0.5U W=0.78U AS=0.3432P AD=0.2028P
+ PS=2.44U PD=1.3U
M$31 VDD \$51 \$50 VDD pfet_05v0 L=0.5U W=0.78U AS=0.2028P AD=0.3276P PS=1.3U
+ PD=1.62U
M$32 \$51 \$42 VDD VDD pfet_05v0 L=0.5U W=0.78U AS=0.3276P AD=0.3432P PS=1.62U
+ PD=2.44U
M$33 A1|A2|Q \$51 VDD VDD pfet_05v0 L=0.5U W=1.215U AS=0.5346P AD=0.6561P
+ PS=3.31U PD=3.51U
M$34 \$63 A1|Q|REC_EN \$43 VDD pfet_05v0 L=0.5U W=0.565U AS=0.2486P AD=0.1469P
+ PS=2.01U PD=1.085U
M$35 \$63 MODE VDD VDD pfet_05v0 L=0.5U W=0.565U AS=0.38705P AD=0.1469P
+ PS=2.08U PD=1.085U
M$36 \$44 \$43 VDD VDD pfet_05v0 L=0.5U W=1.22U AS=0.38705P AD=0.5368P PS=2.08U
+ PD=3.32U
M$37 \$35 A1|A2|Q \$4 VSS nfet_05v0 L=0.6U W=0.365U AS=0.1606P AD=0.0584P
+ PS=1.61U PD=0.685U
M$38 VSS MODE \$35 VSS nfet_05v0 L=0.6U W=0.365U AS=0.0584P AD=0.23405P
+ PS=0.685U PD=1.555U
M$39 \$5 \$4 VSS VSS nfet_05v0 L=0.6U W=0.815U AS=0.23405P AD=0.3586P PS=1.555U
+ PD=2.51U
M$40 \$14 \$5 VSS VSS nfet_05v0 L=0.6U W=0.36U AS=0.1584P AD=0.0936P PS=1.6U
+ PD=0.88U
M$41 \$15 \$6 \$14 VSS nfet_05v0 L=0.6U W=0.36U AS=0.0936P AD=0.0936P PS=0.88U
+ PD=0.88U
M$42 \$38 \$7 \$15 VSS nfet_05v0 L=0.6U W=0.36U AS=0.0936P AD=0.0432P PS=0.88U
+ PD=0.6U
M$43 \$39 \$16 \$38 VSS nfet_05v0 L=0.6U W=0.36U AS=0.0432P AD=0.0432P PS=0.6U
+ PD=0.6U
M$44 VSS RN|SETN \$39 VSS nfet_05v0 L=0.6U W=0.36U AS=0.0432P AD=0.2016P
+ PS=0.6U PD=1.48U
M$45 VSS \$15 \$16 VSS nfet_05v0 L=0.6U W=0.36U AS=0.2007P AD=0.2016P PS=1.475U
+ PD=1.48U
M$46 \$9 \$7 \$16 VSS nfet_05v0 L=0.6U W=0.36U AS=0.2007P AD=0.2007P PS=1.475U
+ PD=1.475U
M$47 \$17 \$6 \$9 VSS nfet_05v0 L=0.6U W=0.36U AS=0.2007P AD=0.0945P PS=1.475U
+ PD=0.885U
M$48 VSS \$18 \$17 VSS nfet_05v0 L=0.6U W=0.36U AS=0.0945P AD=0.1224P PS=0.885U
+ PD=1.04U
M$49 \$41 RN|SETN VSS VSS nfet_05v0 L=0.6U W=0.36U AS=0.1224P AD=0.134P
+ PS=1.04U PD=1.1U
M$50 \$18 \$9 \$41 VSS nfet_05v0 L=0.6U W=0.4U AS=0.134P AD=0.176P PS=1.1U
+ PD=1.68U
M$51 VSS CLK \$6 VSS nfet_05v0 L=0.6U W=0.405U AS=0.1782P AD=0.1053P PS=1.69U
+ PD=0.925U
M$52 \$7 \$6 VSS VSS nfet_05v0 L=0.6U W=0.405U AS=0.1053P AD=0.1782P PS=0.925U
+ PD=1.69U
M$53 TREAT_EN A1|Q|REC_EN VSS VSS nfet_05v0 L=0.6U W=0.565U AS=0.2486P
+ AD=0.1469P PS=2.01U PD=1.085U
M$54 VSS A1|A2|Q TREAT_EN VSS nfet_05v0 L=0.6U W=0.565U AS=0.1469P AD=0.2486P
+ PS=1.085U PD=2.01U
M$55 A1|Q|REC_EN \$18 VSS VSS nfet_05v0 L=0.6U W=0.815U AS=0.3586P AD=0.427875P
+ PS=2.51U PD=2.68U
M$56 \$43 A1|Q|REC_EN VSS VSS nfet_05v0 L=0.6U W=0.36U AS=0.1584P AD=0.0936P
+ PS=1.6U PD=0.88U
M$57 \$43 MODE VSS VSS nfet_05v0 L=0.6U W=0.36U AS=0.2288P AD=0.0936P PS=1.58U
+ PD=0.88U
M$58 \$44 \$43 VSS VSS nfet_05v0 L=0.6U W=0.82U AS=0.2288P AD=0.3608P PS=1.58U
+ PD=2.52U
M$59 \$46 \$44 VSS VSS nfet_05v0 L=0.6U W=0.36U AS=0.1584P AD=0.0936P PS=1.6U
+ PD=0.88U
M$60 \$48 \$45 \$46 VSS nfet_05v0 L=0.6U W=0.36U AS=0.0936P AD=0.0936P PS=0.88U
+ PD=0.88U
M$61 \$61 \$47 \$48 VSS nfet_05v0 L=0.6U W=0.36U AS=0.0936P AD=0.0621P PS=0.88U
+ PD=0.705U
M$62 VSS \$49 \$61 VSS nfet_05v0 L=0.6U W=0.36U AS=0.0621P AD=0.0936P PS=0.705U
+ PD=0.88U
M$63 \$59 \$48 VSS VSS nfet_05v0 L=0.6U W=0.36U AS=0.0936P AD=0.0864P PS=0.88U
+ PD=0.84U
M$64 \$49 RN|SETN \$59 VSS nfet_05v0 L=0.6U W=0.36U AS=0.0864P AD=0.1989P
+ PS=0.84U PD=1.465U
M$65 \$42 \$47 \$49 VSS nfet_05v0 L=0.6U W=0.36U AS=0.1989P AD=0.0936P
+ PS=1.465U PD=0.88U
M$66 \$50 \$45 \$42 VSS nfet_05v0 L=0.6U W=0.36U AS=0.0936P AD=0.2898P PS=0.88U
+ PD=2.33U
M$67 VSS CLK \$45 VSS nfet_05v0 L=0.6U W=0.405U AS=0.1782P AD=0.1053P PS=1.69U
+ PD=0.925U
M$68 \$47 \$45 VSS VSS nfet_05v0 L=0.6U W=0.405U AS=0.1053P AD=0.1782P
+ PS=0.925U PD=1.69U
M$69 \$58 RN|SETN \$50 VSS nfet_05v0 L=0.6U W=0.405U AS=0.3123P AD=0.0486P
+ PS=2.38U PD=0.645U
M$70 VSS \$51 \$58 VSS nfet_05v0 L=0.6U W=0.405U AS=0.0486P AD=0.14985P
+ PS=0.645U PD=1.145U
M$71 \$51 \$42 VSS VSS nfet_05v0 L=0.6U W=0.405U AS=0.14985P AD=0.1782P
+ PS=1.145U PD=1.69U
M$72 A1|A2|Q \$51 VSS VSS nfet_05v0 L=0.6U W=0.815U AS=0.3586P AD=0.3586P
+ PS=2.51U PD=2.51U
.ENDS FSM2
