* Extracted by KLayout with GF180MCU LVS runset on : 12/06/2026 20:21

.SUBCKT gf180mcu_fd_sc_mcu7t5v0__mux2_1 VSS Z S I0 I1 VDD gf180mcu_gnd
M$1 VDD \$2 Z \$10 pfet_05v0 L=0.5U W=1.22U AS=0.5368P AD=0.4298375P PS=3.32U
+ PD=2.185U
M$2 \$11 I1 VDD \$10 pfet_05v0 L=0.5U W=0.615U AS=0.4298375P AD=0.0845625P
+ PS=2.185U PD=0.89U
M$3 \$2 \$3 \$11 \$10 pfet_05v0 L=0.5U W=0.615U AS=0.0845625P AD=0.1599P
+ PS=0.89U PD=1.135U
M$4 \$12 S \$2 \$10 pfet_05v0 L=0.5U W=0.615U AS=0.1599P AD=0.0738P PS=1.135U
+ PD=0.855U
M$5 VDD I0 \$12 \$10 pfet_05v0 L=0.5U W=0.615U AS=0.0738P AD=0.1599P PS=0.855U
+ PD=1.135U
M$6 \$3 S VDD \$10 pfet_05v0 L=0.5U W=0.615U AS=0.1599P AD=0.2706P PS=1.135U
+ PD=2.11U
M$7 \$13 I1 VSS gf180mcu_gnd nfet_05v0 L=0.6U W=0.36U AS=0.218P AD=0.0432P
+ PS=1.52U PD=0.6U
M$8 \$2 S \$13 gf180mcu_gnd nfet_05v0 L=0.6U W=0.36U AS=0.0432P AD=0.0936P
+ PS=0.6U PD=0.88U
M$9 \$14 \$3 \$2 gf180mcu_gnd nfet_05v0 L=0.6U W=0.36U AS=0.0936P AD=0.0432P
+ PS=0.88U PD=0.6U
M$10 VSS I0 \$14 gf180mcu_gnd nfet_05v0 L=0.6U W=0.36U AS=0.0432P AD=0.0936P
+ PS=0.6U PD=0.88U
M$11 \$3 S VSS gf180mcu_gnd nfet_05v0 L=0.6U W=0.36U AS=0.0936P AD=0.1584P
+ PS=0.88U PD=1.6U
M$12 VSS \$2 Z gf180mcu_gnd nfet_05v0 L=0.6U W=0.82U AS=0.3608P AD=0.218P
+ PS=2.52U PD=1.52U
.ENDS gf180mcu_fd_sc_mcu7t5v0__mux2_1
