* Extracted by KLayout with GF180MCU LVS runset on : 12/06/2026 18:06

.SUBCKT gf180mcu_fd_sc_mcu7t5v0__nor2_1 VSS A2 A1 VDD ZN VPW
M$1 \$8 A2 VDD \$7 pfet_05v0 L=0.5U W=1.22U AS=0.5368P AD=0.4087P PS=3.32U
+ PD=1.89U
M$2 ZN A1 \$8 \$7 pfet_05v0 L=0.5U W=1.22U AS=0.4087P AD=0.5368P PS=1.89U
+ PD=3.32U
M$3 ZN A2 VSS VPW nfet_05v0 L=0.6U W=0.565U AS=0.2486P AD=0.1469P PS=2.01U
+ PD=1.085U
M$4 VSS A1 ZN VPW nfet_05v0 L=0.6U W=0.565U AS=0.1469P AD=0.2486P PS=1.085U
+ PD=2.01U
.ENDS gf180mcu_fd_sc_mcu7t5v0__nor2_1
