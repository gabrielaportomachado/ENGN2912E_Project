* Extracted by KLayout with GF180MCU LVS runset on : 20/05/2026 22:57

.SUBCKT gf180mcu_fd_sc_mcu7t5v0__dffrnq_1 VSS RN Q CLK D VDD VPW
M$1 \$8 D VDD \$28 pfet_05v0 L=0.5U W=0.78U AS=0.3432P AD=0.2028P PS=2.44U
+ PD=1.3U
M$2 \$10 \$9 \$8 \$28 pfet_05v0 L=0.5U W=0.78U AS=0.2028P AD=0.2028P PS=1.3U
+ PD=1.3U
M$3 \$22 \$5 \$10 \$28 pfet_05v0 L=0.5U W=0.78U AS=0.2028P AD=0.2028P PS=1.3U
+ PD=1.3U
M$4 VDD \$11 \$22 \$28 pfet_05v0 L=0.5U W=0.78U AS=0.2028P AD=0.45P PS=1.3U
+ PD=2.02U
M$5 \$22 RN VDD \$28 pfet_05v0 L=0.5U W=0.78U AS=0.45P AD=0.3432P PS=2.02U
+ PD=2.44U
M$6 \$11 \$10 VDD \$28 pfet_05v0 L=0.5U W=0.505U AS=0.2222P AD=0.2424P PS=1.89U
+ PD=1.465U
M$7 \$12 \$5 \$11 \$28 pfet_05v0 L=0.5U W=0.505U AS=0.2424P AD=0.2537625P
+ PS=1.465U PD=1.51U
M$8 \$13 \$9 \$12 \$28 pfet_05v0 L=0.5U W=0.505U AS=0.2537625P AD=0.1313P
+ PS=1.51U PD=1.025U
M$9 \$13 \$14 VDD \$28 pfet_05v0 L=0.5U W=0.505U AS=0.29465P AD=0.1313P
+ PS=1.74U PD=1.025U
M$10 \$14 RN VDD \$28 pfet_05v0 L=0.5U W=1U AS=0.29465P AD=0.26P PS=1.74U
+ PD=1.52U
M$11 VDD \$12 \$14 \$28 pfet_05v0 L=0.5U W=1U AS=0.26P AD=0.44P PS=1.52U
+ PD=2.88U
M$12 VDD CLK \$5 \$28 pfet_05v0 L=0.5U W=0.865U AS=0.3806P AD=0.2249P PS=2.61U
+ PD=1.385U
M$13 \$9 \$5 VDD \$28 pfet_05v0 L=0.5U W=0.865U AS=0.2249P AD=0.3806P PS=1.385U
+ PD=2.61U
M$14 Q \$14 VDD \$28 pfet_05v0 L=0.5U W=1.215U AS=0.5346P AD=0.5346P PS=3.31U
+ PD=3.31U
M$15 \$8 D VSS VPW nfet_05v0 L=0.6U W=0.36U AS=0.1584P AD=0.0936P PS=1.6U
+ PD=0.88U
M$16 \$10 \$5 \$8 VPW nfet_05v0 L=0.6U W=0.36U AS=0.0936P AD=0.0936P PS=0.88U
+ PD=0.88U
M$17 \$19 \$9 \$10 VPW nfet_05v0 L=0.6U W=0.36U AS=0.0936P AD=0.0432P PS=0.88U
+ PD=0.6U
M$18 \$20 \$11 \$19 VPW nfet_05v0 L=0.6U W=0.36U AS=0.0432P AD=0.0432P PS=0.6U
+ PD=0.6U
M$19 \$20 RN VSS VPW nfet_05v0 L=0.6U W=0.36U AS=0.2016P AD=0.0432P PS=1.48U
+ PD=0.6U
M$20 \$11 \$10 VSS VPW nfet_05v0 L=0.6U W=0.36U AS=0.2016P AD=0.2007P PS=1.48U
+ PD=1.475U
M$21 \$12 \$9 \$11 VPW nfet_05v0 L=0.6U W=0.36U AS=0.2007P AD=0.2007P PS=1.475U
+ PD=1.475U
M$22 \$13 \$5 \$12 VPW nfet_05v0 L=0.6U W=0.36U AS=0.2007P AD=0.0945P PS=1.475U
+ PD=0.885U
M$23 VSS \$14 \$13 VPW nfet_05v0 L=0.6U W=0.36U AS=0.0945P AD=0.1224P PS=0.885U
+ PD=1.04U
M$24 VSS RN \$18 VPW nfet_05v0 L=0.6U W=0.36U AS=0.134P AD=0.1224P PS=1.1U
+ PD=1.04U
M$25 \$14 \$12 \$18 VPW nfet_05v0 L=0.6U W=0.4U AS=0.134P AD=0.176P PS=1.1U
+ PD=1.68U
M$26 VSS CLK \$5 VPW nfet_05v0 L=0.6U W=0.405U AS=0.1782P AD=0.1053P PS=1.69U
+ PD=0.925U
M$27 \$9 \$5 VSS VPW nfet_05v0 L=0.6U W=0.405U AS=0.1053P AD=0.1782P PS=0.925U
+ PD=1.69U
M$28 Q \$14 VSS VPW nfet_05v0 L=0.6U W=0.815U AS=0.3586P AD=0.3586P PS=2.51U
+ PD=2.51U
.ENDS gf180mcu_fd_sc_mcu7t5v0__dffrnq_1
