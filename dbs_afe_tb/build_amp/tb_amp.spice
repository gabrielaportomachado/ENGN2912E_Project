* one amplifier channel: bias_genc + amp_ch (generated by gen_amp_tb.py)
.lib /foss/pdks/gf180mcuD/libs.tech/ngspice/sm141064.ngspice typical
.lib /foss/pdks/gf180mcuD/libs.tech/ngspice/sm141064.ngspice res_typical
.lib /foss/pdks/gf180mcuD/libs.tech/ngspice/sm141064.ngspice mimcap_typical
.lib /foss/pdks/gf180mcuD/libs.tech/ngspice/sm141064.ngspice moscap_typical
.lib /foss/pdks/gf180mcuD/libs.tech/ngspice/sm141064.ngspice diode_typical
.include /foss/pdks/gf180mcuD/libs.tech/ngspice/design.ngspice
.include /foss/designs/final_project/AFE/layout/lvs/afe_chc.spice
.include /foss/designs/final_project/AFE/layout/lvs/bias_genc.spice
Vdd vdd 0 pwl(0 0 2u 3.3)
Vref ref 0 1.65
Vrec rec 0 sin(1.65 0.00045 200 0 0)
Vrst rst_amp 0 pwl(0 0 2u 3.3 0.001 3.3 0.001000001 0)
Vswr sw_rec 0 pwl(0 0 0.001 0 0.001000001 3.3)
Vswrb sw_rec_b 0 pwl(0 0 2u 3.3 0.001 3.3 0.001000001 0)
Xu_bias vbn vcm vg1 vcmo vg2 vrs vdd 0 bias_genc
Xamp rec ref sw_rec sw_rec_b rst_amp vbn vcm vg1 vcmo vg2 vrs out vdd 0 amp_ch
Cload out 0 2e-12
.options abstol=1e-12 reltol=1e-3 method=gear
.temp 27
.save v(out) v(rec) v(vcmo) v(vbn) v(vcm)
.tran 10u 0.03 0 20u
.control
set num_threads=1
set wr_singlescale
set wr_vecnames
run
wrdata amp_out.txt v(out) v(rec) v(vcmo)
.endc
.end
