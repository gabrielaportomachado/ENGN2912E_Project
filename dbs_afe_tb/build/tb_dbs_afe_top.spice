* dbs_afe_top testbench (generated by gen_xschem_tb.py)
.lib /foss/pdks/gf180mcuD/libs.tech/ngspice/sm141064.ngspice typical
.lib /foss/pdks/gf180mcuD/libs.tech/ngspice/sm141064.ngspice res_typical
.lib /foss/pdks/gf180mcuD/libs.tech/ngspice/sm141064.ngspice mimcap_typical
.lib /foss/pdks/gf180mcuD/libs.tech/ngspice/sm141064.ngspice moscap_typical
.lib /foss/pdks/gf180mcuD/libs.tech/ngspice/sm141064.ngspice diode_typical
.lib /foss/pdks/gf180mcuD/libs.tech/ngspice/sm141064.ngspice bjt_t
.include /foss/pdks/gf180mcuD/libs.tech/ngspice/design.ngspice
.include /foss/pdks/gf180mcuD/libs.ref/gf180mcu_fd_sc_mcu7t5v0/spice/gf180mcu_fd_sc_mcu7t5v0.spice
.include /foss/designs/final_project/dbs_afe_tb/build/afe_dig.spice
.include /foss/designs/final_project/AFE/layout/lvs/dbs_afe_top.spice
.include stim.inc
Vdd vdd 0 pwl(0 0 2u 3.3)
Xdut e3 e2 e1 e0 ipg3 ipg2 ipg1 ipg0 rec3 rec2 rec1 rec0 ref cs din sclk rstn dout dout_in dout_oe dout_ie dout_pd dout_pu dout_cs dout_sl dout_pdrv0 dout_pdrv1 cs_pu cs_pd din_pu din_pd sclk_pu sclk_pd rstn_pu rstn_pd vdd 0 dbs_afe_top
Cdout dout 0 15p
Ripg0 ipg0 ref 1g
Ripg1 ipg1 ref 1g
Ripg2 ipg2 ref 1g
Ripg3 ipg3 ref 1g
Rrec0 rec0 0 1e13
Rrec1 rec1 0 1e13
Rrec2 rec2 0 1e13
Rrec3 rec3 0 1e13
Rfl_dout_in dout_in 0 1g
Rfl_dout_oe dout_oe 0 1g
Rfl_dout_ie dout_ie 0 1g
Rfl_dout_pd dout_pd 0 1g
Rfl_dout_pu dout_pu 0 1g
Rfl_dout_cs dout_cs 0 1g
Rfl_dout_sl dout_sl 0 1g
Rfl_dout_pdrv0 dout_pdrv0 0 1g
Rfl_dout_pdrv1 dout_pdrv1 0 1g
Rfl_cs_pu cs_pu 0 1g
Rfl_cs_pd cs_pd 0 1g
Rfl_din_pu din_pu 0 1g
Rfl_din_pd din_pd 0 1g
Rfl_sclk_pu sclk_pu 0 1g
Rfl_sclk_pd sclk_pd 0 1g
Rfl_rstn_pu rstn_pu 0 1g
Rfl_rstn_pd rstn_pd 0 1g
.options abstol=1e-12 reltol=1e-3 method=gear
.temp 27
.tran 50n 0.03 0 200n
.control
set num_threads=1
set wr_singlescale
set wr_vecnames
run
wrdata tb_out.txt v(cs) v(sclk) v(din) v(dout) v(e0) v(e1) v(vdd)
.endc
.end
